* SPICE3 file created from bootstrapped.ext - technology: gf180mcuD

.subckt pfet a_28_n136# a_n92_0# w_n230_n138# VSUBS
X0 w_n230_n138# a_28_n136# a_n92_0# w_n230_n138# pfet_03v3 ad=1.38p pd=4.76u as=0.65p ps=3.3u w=1u l=0.28u
C0 a_n92_0# w_n230_n138# 0.0352f
C1 a_28_n136# w_n230_n138# 0.14751f
C2 a_28_n136# a_n92_0# 0.00351f
C3 a_n92_0# VSUBS 0.03098f
C4 a_28_n136# VSUBS 0.08197f
C5 w_n230_n138# VSUBS 1.08986f
.ends

.subckt cap_mim m4_n120_n120# m4_0_0# VSUBS
X0 m4_0_0# m4_n120_n120# cap_mim_2f0_m4m5_noshield c_width=11u c_length=9.1u
C0 m4_0_0# m4_n120_n120# 0.5949f
C1 m4_0_0# VSUBS 1.92846f
C2 m4_n120_n120# VSUBS 1.46119f
.ends

.subckt nfet$5 a_30_360# a_n84_0# a_94_0# VSUBS
X0 a_94_0# a_30_360# a_n84_0# VSUBS nfet_03v3 ad=0.915p pd=4.22u as=0.915p ps=4.22u w=1.5u l=0.28u
C0 a_94_0# a_30_360# 0.00763f
C1 a_n84_0# a_30_360# 0.00763f
C2 a_n84_0# a_94_0# 0.06103f
C3 a_94_0# VSUBS 0.06142f
C4 a_n84_0# VSUBS 0.06142f
C5 a_30_360# VSUBS 0.21929f
.ends

.subckt nfet a_n84_0# a_94_0# a_30_160# VSUBS
X0 a_94_0# a_30_160# a_n84_0# VSUBS nfet_03v3 ad=0.305p pd=2.22u as=0.305p ps=2.22u w=0.5u l=0.28u
C0 a_94_0# a_30_160# 0.00325f
C1 a_n84_0# a_30_160# 0.00325f
C2 a_n84_0# a_94_0# 0.02606f
C3 a_94_0# VSUBS 0.04417f
C4 a_n84_0# VSUBS 0.04417f
C5 a_30_160# VSUBS 0.22246f
.ends

.subckt pfet$3 a_28_n136# w_n180_n88# a_n92_0# a_94_0# VSUBS
X0 a_94_0# a_28_n136# a_n92_0# w_n180_n88# pfet_03v3 ad=0.325p pd=2.3u as=0.325p ps=2.3u w=0.5u l=0.28u
C0 a_94_0# a_n92_0# 0.02488f
C1 a_28_n136# a_94_0# 0.00321f
C2 a_n92_0# w_n180_n88# 0.00716f
C3 a_28_n136# w_n180_n88# 0.09243f
C4 a_94_0# w_n180_n88# 0.00716f
C5 a_28_n136# a_n92_0# 0.00321f
C6 a_94_0# VSUBS 0.0369f
C7 a_n92_0# VSUBS 0.0369f
C8 a_28_n136# VSUBS 0.13535f
C9 w_n180_n88# VSUBS 0.40738f
.ends

.subckt pfet$1 a_n92_0# a_28_260# w_n230_n138# VSUBS
X0 w_n230_n138# a_28_260# a_n92_0# w_n230_n138# pfet_03v3 ad=1.38p pd=4.76u as=0.65p ps=3.3u w=1u l=0.28u
C0 a_n92_0# w_n230_n138# 0.0352f
C1 a_28_260# w_n230_n138# 0.14751f
C2 a_28_260# a_n92_0# 0.00351f
C3 a_n92_0# VSUBS 0.03098f
C4 a_28_260# VSUBS 0.08197f
C5 w_n230_n138# VSUBS 1.08986f
.ends

.subckt nfet$4 a_30_n132# a_n84_0# a_94_0# VSUBS
X0 a_94_0# a_30_n132# a_n84_0# VSUBS nfet_03v3 ad=0.305p pd=2.22u as=0.305p ps=2.22u w=0.5u l=0.28u
C0 a_94_0# a_30_n132# 0.00325f
C1 a_n84_0# a_30_n132# 0.00325f
C2 a_n84_0# a_94_0# 0.02606f
C3 a_94_0# VSUBS 0.04417f
C4 a_n84_0# VSUBS 0.04417f
C5 a_30_n132# VSUBS 0.22246f
.ends

.subckt bootstrapped VDD VSS CLK VIN VOUT
Xpfet_0 m2_3352_405# m3_3464_703# w_4010_1117# pfet_0/VSUBS pfet
Xcap_mim_0 m4_2440_331# w_4010_1117# pfet_0/VSUBS cap_mim
Xnfet$5_0 m3_3464_703# VIN VOUT pfet_0/VSUBS nfet$5
Xnfet_0 m2_4436_350# VSS m3_2756_199# pfet_0/VSUBS nfet
Xnfet_1 VSS m2_4436_350# m3_2756_199# pfet_0/VSUBS nfet
Xnfet_2 VSS m3_2756_199# CLK pfet_0/VSUBS nfet
Xnfet_3 m4_2440_331# m2_3352_405# CLK pfet_0/VSUBS nfet
Xnfet_4 m4_2440_331# m2_3352_405# m3_3464_703# pfet_0/VSUBS nfet
Xpfet$3_0 CLK w_2134_1117# VDD m3_2756_199# pfet_0/VSUBS pfet$3
Xnfet_5 m4_2440_331# VIN m3_3464_703# pfet_0/VSUBS nfet
Xpfet$3_1 CLK w_2134_1117# m3_2756_199# VDD pfet_0/VSUBS pfet$3
Xpfet$3_2 CLK w_2134_1117# VDD m2_3352_405# pfet_0/VSUBS pfet$3
Xpfet$1_0 VDD m3_3464_703# w_4010_1117# pfet_0/VSUBS pfet$1
Xpfet$3_3 CLK w_2134_1117# m2_3352_405# VDD pfet_0/VSUBS pfet$3
Xnfet$4_0 VDD m3_3464_703# m2_4436_350# pfet_0/VSUBS nfet$4
Xnfet$4_1 VDD m2_4436_350# m3_3464_703# pfet_0/VSUBS nfet$4
Xnfet$4_2 m3_2756_199# m4_2440_331# VSS pfet_0/VSUBS nfet$4
C0 VSS VIN 0.10184f
C1 VSS m2_3352_405# 0.13676f
C2 w_2134_1117# m3_2756_199# 0.03547f
C3 VIN m2_5152_227# 0.03414f
C4 m2_4436_350# VIN 0.30459f
C5 m2_3352_405# m2_4436_350# 0.00136f
C6 VIN m4_2440_331# 0.06555f
C7 VIN m3_3464_703# 0.24862f
C8 m2_3352_405# m4_2440_331# 0.10031f
C9 m2_3352_405# m3_3464_703# 0.46414f
C10 VSS VDD 0.42164f
C11 VDD m2_5152_227# 0.00301f
C12 VDD m2_4436_350# 0.12352f
C13 w_4010_1117# m3_2756_199# 0.08768f
C14 VDD m4_2440_331# 0.08567f
C15 VDD m3_3464_703# 0.50458f
C16 CLK m3_2756_199# 0.58914f
C17 w_4010_1117# w_2134_1117# 0.07918f
C18 VSS m2_5152_227# 0.01157f
C19 VSS m2_4436_350# 0.16244f
C20 m2_4436_350# m2_5152_227# 0.00109f
C21 VSS m4_2440_331# 0.15886f
C22 VSS m3_3464_703# 0.62001f
C23 VIN m3_2756_199# 0.40715f
C24 m2_4436_350# m4_2440_331# 0
C25 m2_5152_227# m4_2440_331# 0
C26 m2_4436_350# m3_3464_703# 0.05687f
C27 m3_3464_703# m2_5152_227# 0.01423f
C28 m2_3352_405# m3_2756_199# 0.05151f
C29 CLK w_2134_1117# 0.34536f
C30 m3_3464_703# m4_2440_331# 0.03529f
C31 VOUT VIN 0.04806f
C32 VDD m3_2756_199# 0.12788f
C33 VDD VOUT 0
C34 w_4010_1117# CLK 0.06669f
C35 m2_3352_405# w_2134_1117# 0.06571f
C36 VDD w_2134_1117# 0.98166f
C37 w_4010_1117# VIN 0.00453f
C38 w_4010_1117# m2_3352_405# 0.33702f
C39 VSS m3_2756_199# 0.77643f
C40 m2_5152_227# m3_2756_199# 0.00685f
C41 m2_4436_350# m3_2756_199# 0.09525f
C42 VDD w_4010_1117# 0.53044f
C43 VSS VOUT 0.0989f
C44 m4_2440_331# m3_2756_199# 0.22885f
C45 m3_3464_703# m3_2756_199# 0.04832f
C46 VOUT m2_5152_227# 0.0394f
C47 m2_4436_350# VOUT 0
C48 CLK VIN 0
C49 m2_3352_405# CLK 0.31687f
C50 VOUT m4_2440_331# 0
C51 VOUT m3_3464_703# 0.01008f
C52 VSS w_2134_1117# 0.0173f
C53 VDD CLK 0.41267f
C54 w_2134_1117# m4_2440_331# 0.07061f
C55 w_2134_1117# m3_3464_703# 0.01431f
C56 m2_3352_405# VIN 0.00495f
C57 VSS w_4010_1117# 0.33315f
C58 w_4010_1117# m2_5152_227# 0.0016f
C59 w_4010_1117# m2_4436_350# 0.01854f
C60 VDD VIN 0.02321f
C61 VDD m2_3352_405# 0.57898f
C62 w_4010_1117# m4_2440_331# 0.07482f
C63 w_4010_1117# m3_3464_703# 0.70048f
C64 VSS CLK 0.158f
C65 CLK m2_4436_350# 0
C66 VOUT m3_2756_199# 0.00102f
C67 CLK m4_2440_331# 0.12801f
C68 CLK m3_3464_703# 0.04611f
C69 m2_5152_227# pfet_0/VSUBS 0.09603f **FLOATING
C70 m2_4436_350# pfet_0/VSUBS -0.3066f
C71 m3_2756_199# pfet_0/VSUBS -0.4431f
C72 VDD pfet_0/VSUBS -2.35543f
C73 m4_2440_331# pfet_0/VSUBS -0.40454f
C74 m3_3464_703# pfet_0/VSUBS -0.64137f
C75 w_4010_1117# pfet_0/VSUBS 0.85773f
C76 VIN pfet_0/VSUBS -0.2743f
C77 w_2134_1117# pfet_0/VSUBS 2.8808f
C78 m2_3352_405# pfet_0/VSUBS -0.64218f
C79 VSS pfet_0/VSUBS -1.33135f
C80 CLK pfet_0/VSUBS -1.33366f
C81 VOUT pfet_0/VSUBS -0.02641f
.ends
