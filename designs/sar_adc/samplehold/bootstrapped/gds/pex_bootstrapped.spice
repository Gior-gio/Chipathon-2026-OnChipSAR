* SPICE3 file created from bootstrapped.ext - technology: gf180mcuD

.subckt pfet a_28_n136# a_n92_0# w_n230_n138# VSUBS
X0 w_n230_n138# a_28_n136# a_n92_0# w_n230_n138# pfet_03v3 ad=1.38p pd=4.76u as=0.65p ps=3.3u w=1u l=0.28u
C0 a_28_n136# w_n230_n138# 0.14751f
C1 a_28_n136# a_n92_0# 0.00351f
C2 a_n92_0# w_n230_n138# 0.0352f
C3 a_n92_0# VSUBS 0.03098f
C4 a_28_n136# VSUBS 0.08197f
C5 w_n230_n138# VSUBS 1.08986f
.ends

.subckt cap_mim m4_n120_n120# m4_0_0# VSUBS
X0 m4_0_0# m4_n120_n120# cap_mim_2f0_m4m5_noshield c_width=11u c_length=9.1u
C0 m4_0_0# m4_n120_n120# 0.5949f
C1 m4_0_0# VSUBS 1.92846f
C2 m4_n120_n120# VSUBS 1.46119f
.ends

.subckt nfet$5 a_30_360# a_n84_0# a_94_0# VSUBS
X0 a_94_0# a_30_360# a_n84_0# VSUBS nfet_03v3 ad=0.915p pd=4.22u as=0.915p ps=4.22u w=1.5u l=0.28u
C0 a_n84_0# a_30_360# 0.00763f
C1 a_n84_0# a_94_0# 0.06103f
C2 a_94_0# a_30_360# 0.00763f
C3 a_94_0# VSUBS 0.06142f
C4 a_n84_0# VSUBS 0.06142f
C5 a_30_360# VSUBS 0.21929f
.ends

.subckt nfet a_n84_0# a_94_0# a_30_160# VSUBS
X0 a_94_0# a_30_160# a_n84_0# VSUBS nfet_03v3 ad=0.305p pd=2.22u as=0.305p ps=2.22u w=0.5u l=0.28u
C0 a_n84_0# a_30_160# 0.00325f
C1 a_n84_0# a_94_0# 0.02606f
C2 a_94_0# a_30_160# 0.00325f
C3 a_94_0# VSUBS 0.04417f
C4 a_n84_0# VSUBS 0.04417f
C5 a_30_160# VSUBS 0.22246f
.ends

.subckt pfet$3 a_28_n136# w_n180_n88# a_n92_0# a_94_0# VSUBS
X0 a_94_0# a_28_n136# a_n92_0# w_n180_n88# pfet_03v3 ad=0.325p pd=2.3u as=0.325p ps=2.3u w=0.5u l=0.28u
C0 a_28_n136# w_n180_n88# 0.09243f
C1 a_28_n136# a_n92_0# 0.00321f
C2 a_n92_0# w_n180_n88# 0.00716f
C3 a_28_n136# a_94_0# 0.00321f
C4 w_n180_n88# a_94_0# 0.00716f
C5 a_n92_0# a_94_0# 0.02488f
C6 a_94_0# VSUBS 0.0369f
C7 a_n92_0# VSUBS 0.0369f
C8 a_28_n136# VSUBS 0.13535f
C9 w_n180_n88# VSUBS 0.40738f
.ends

.subckt pfet$1 a_n92_0# a_28_260# w_n230_n138# VSUBS
X0 w_n230_n138# a_28_260# a_n92_0# w_n230_n138# pfet_03v3 ad=1.38p pd=4.76u as=0.65p ps=3.3u w=1u l=0.28u
C0 a_28_260# w_n230_n138# 0.14751f
C1 a_28_260# a_n92_0# 0.00351f
C2 a_n92_0# w_n230_n138# 0.0352f
C3 a_n92_0# VSUBS 0.03098f
C4 a_28_260# VSUBS 0.08197f
C5 w_n230_n138# VSUBS 1.08986f
.ends

.subckt nfet$4 a_30_n132# a_n84_0# a_94_0# VSUBS
X0 a_94_0# a_30_n132# a_n84_0# VSUBS nfet_03v3 ad=0.305p pd=2.22u as=0.305p ps=2.22u w=0.5u l=0.28u
C0 a_n84_0# a_30_n132# 0.00325f
C1 a_n84_0# a_94_0# 0.02606f
C2 a_94_0# a_30_n132# 0.00325f
C3 a_94_0# VSUBS 0.04417f
C4 a_n84_0# VSUBS 0.04417f
C5 a_30_n132# VSUBS 0.22246f
.ends

.subckt bootstrapped VDD VSS CLK VIN VOUT
Xpfet_0 m2_3352_405# m3_3464_703# w_4010_1117# pfet_0/VSUBS pfet
Xcap_mim_0 m4_2440_331# w_4010_1117# pfet_0/VSUBS cap_mim
Xnfet$5_0 m3_3464_703# VIN VOUT pfet_0/VSUBS nfet$5
Xnfet_0 m2_4436_350# VSS m3_2756_199# pfet_0/VSUBS nfet
Xnfet_1 VSS m2_4436_350# m3_2756_199# pfet_0/VSUBS nfet
Xnfet_2 VSS m3_2756_199# CLK pfet_0/VSUBS nfet
Xnfet_3 m4_2440_331# m2_3352_405# CLK pfet_0/VSUBS nfet
Xnfet_4 m4_2440_331# m2_3352_405# m3_3464_703# pfet_0/VSUBS nfet
Xpfet$3_0 CLK w_2134_1117# VDD m3_2756_199# pfet_0/VSUBS pfet$3
Xnfet_5 m4_2440_331# VIN m3_3464_703# pfet_0/VSUBS nfet
Xpfet$3_1 CLK w_2134_1117# m3_2756_199# VDD pfet_0/VSUBS pfet$3
Xpfet$3_2 CLK w_2134_1117# VDD m2_3352_405# pfet_0/VSUBS pfet$3
Xpfet$1_0 VDD m3_3464_703# w_4010_1117# pfet_0/VSUBS pfet$1
Xpfet$3_3 CLK w_2134_1117# m2_3352_405# VDD pfet_0/VSUBS pfet$3
Xnfet$4_0 VDD m3_3464_703# m2_4436_350# pfet_0/VSUBS nfet$4
Xnfet$4_1 VDD m2_4436_350# m3_3464_703# pfet_0/VSUBS nfet$4
Xnfet$4_2 m3_2756_199# m4_2440_331# VSS pfet_0/VSUBS nfet$4
C0 VDD VIN 0.02321f
C1 CLK VSS 0.158f
C2 m2_5152_227# m2_4436_350# 0.00109f
C3 VOUT VIN 0.04806f
C4 w_4010_1117# m2_3352_405# 0.33702f
C5 VDD m3_2756_199# 0.12788f
C6 m2_5152_227# VSS 0.01157f
C7 VOUT m3_2756_199# 0.00102f
C8 VDD m2_4436_350# 0.12352f
C9 m3_2756_199# w_2134_1117# 0.03547f
C10 CLK m4_2440_331# 0.12801f
C11 VOUT m2_4436_350# 0
C12 VSS VDD 0.42164f
C13 m3_3464_703# VIN 0.24862f
C14 CLK m2_3352_405# 0.31687f
C15 m2_5152_227# m4_2440_331# 0
C16 VSS VOUT 0.0989f
C17 VSS w_2134_1117# 0.0173f
C18 CLK w_4010_1117# 0.06669f
C19 m3_2756_199# m3_3464_703# 0.04832f
C20 VDD m4_2440_331# 0.08567f
C21 m3_3464_703# m2_4436_350# 0.05687f
C22 m2_5152_227# w_4010_1117# 0.0016f
C23 VOUT m4_2440_331# 0
C24 w_2134_1117# m4_2440_331# 0.07061f
C25 VDD m2_3352_405# 0.57898f
C26 VSS m3_3464_703# 0.62001f
C27 w_4010_1117# VDD 0.53044f
C28 m2_3352_405# w_2134_1117# 0.06571f
C29 w_4010_1117# w_2134_1117# 0.07918f
C30 m3_3464_703# m4_2440_331# 0.03529f
C31 m2_3352_405# m3_3464_703# 0.46414f
C32 CLK VDD 0.41267f
C33 w_4010_1117# m3_3464_703# 0.70048f
C34 m3_2756_199# VIN 0.40715f
C35 CLK w_2134_1117# 0.34536f
C36 m2_5152_227# VDD 0.00301f
C37 VIN m2_4436_350# 0.30459f
C38 m2_5152_227# VOUT 0.0394f
C39 m3_2756_199# m2_4436_350# 0.09525f
C40 VSS VIN 0.10184f
C41 VOUT VDD 0
C42 CLK m3_3464_703# 0.04611f
C43 VDD w_2134_1117# 0.98166f
C44 VSS m3_2756_199# 0.77643f
C45 m2_5152_227# m3_3464_703# 0.01423f
C46 VSS m2_4436_350# 0.16244f
C47 m4_2440_331# VIN 0.06555f
C48 m3_2756_199# m4_2440_331# 0.22885f
C49 m2_3352_405# VIN 0.00495f
C50 VDD m3_3464_703# 0.50458f
C51 VOUT m3_3464_703# 0.01008f
C52 m4_2440_331# m2_4436_350# 0
C53 w_4010_1117# VIN 0.00453f
C54 m3_2756_199# m2_3352_405# 0.05151f
C55 m3_3464_703# w_2134_1117# 0.01431f
C56 VSS m4_2440_331# 0.15886f
C57 w_4010_1117# m3_2756_199# 0.08768f
C58 m2_3352_405# m2_4436_350# 0.00136f
C59 w_4010_1117# m2_4436_350# 0.01854f
C60 VSS m2_3352_405# 0.13676f
C61 CLK VIN 0
C62 VSS w_4010_1117# 0.33315f
C63 CLK m3_2756_199# 0.58914f
C64 m2_5152_227# VIN 0.03414f
C65 m2_3352_405# m4_2440_331# 0.10031f
C66 CLK m2_4436_350# 0
C67 w_4010_1117# m4_2440_331# 0.07482f
C68 m2_5152_227# m3_2756_199# 0.00685f
C69 m2_5152_227# pfet_0/VSUBS 0.09603f
C70 m2_4436_350# pfet_0/VSUBS -0.3066f
C71 m3_2756_199# pfet_0/VSUBS -0.4431f
C72 VDD pfet_0/VSUBS -2.35543f
C73 m4_2440_331# pfet_0/VSUBS -0.40454f
C74 m3_3464_703# pfet_0/VSUBS -0.64137f
C75 w_4010_1117# pfet_0/VSUBS 0.85773f
C76 VIN pfet_0/VSUBS -0.2743f
C77 w_2134_1117# pfet_0/VSUBS 2.8808f
C78 m2_3352_405# pfet_0/VSUBS -0.64218f
C79 VSS pfet_0/VSUBS -1.33135f
C80 CLK pfet_0/VSUBS -1.33366f
C81 VOUT pfet_0/VSUBS -0.02641f
.ends
