* SPICE3 file created from bootstrapped.ext - technology: gf180mcuD

.subckt pfet a_28_n136# a_n92_0# w_n230_n138# VSUBS
X0 w_n230_n138# a_28_n136# a_n92_0# w_n230_n138# pfet_03v3 ad=1.38p pd=4.76u as=0.65p ps=3.3u w=1u l=0.28u
C0 a_n92_0# w_n230_n138# 0.0352f
C1 a_28_n136# w_n230_n138# 0.14751f
C2 a_n92_0# a_28_n136# 0.00351f
C3 a_n92_0# VSUBS 0.03098f
C4 a_28_n136# VSUBS 0.08197f
C5 w_n230_n138# VSUBS 1.08986f
.ends

.subckt cap_mim m4_n120_n120# m4_0_0# VSUBS
X0 m4_0_0# m4_n120_n120# cap_mim_2f0_m4m5_noshield c_width=11u c_length=9.1u
C0 m4_0_0# m4_n120_n120# 0.5949f
C1 m4_0_0# VSUBS 1.92846f
C2 m4_n120_n120# VSUBS 1.46119f
.ends

.subckt nfet$5 a_30_360# a_n84_0# a_94_0# VSUBS
X0 a_94_0# a_30_360# a_n84_0# VSUBS nfet_03v3 ad=0.915p pd=4.22u as=0.915p ps=4.22u w=1.5u l=0.28u
C0 a_94_0# a_30_360# 0.00763f
C1 a_n84_0# a_30_360# 0.00763f
C2 a_94_0# a_n84_0# 0.06103f
C3 a_94_0# VSUBS 0.06142f
C4 a_n84_0# VSUBS 0.06142f
C5 a_30_360# VSUBS 0.21929f
.ends

.subckt nfet a_n84_0# a_94_0# a_30_160# VSUBS
X0 a_94_0# a_30_160# a_n84_0# VSUBS nfet_03v3 ad=0.305p pd=2.22u as=0.305p ps=2.22u w=0.5u l=0.28u
C0 a_94_0# a_30_160# 0.00325f
C1 a_n84_0# a_30_160# 0.00325f
C2 a_94_0# a_n84_0# 0.02606f
C3 a_94_0# VSUBS 0.04417f
C4 a_n84_0# VSUBS 0.04417f
C5 a_30_160# VSUBS 0.22246f
.ends

.subckt pfet$3 a_28_n136# w_n180_n88# a_n92_0# a_94_0# VSUBS
X0 a_94_0# a_28_n136# a_n92_0# w_n180_n88# pfet_03v3 ad=0.325p pd=2.3u as=0.325p ps=2.3u w=0.5u l=0.28u
C0 a_n92_0# w_n180_n88# 0.00716f
C1 a_28_n136# a_94_0# 0.00321f
C2 a_28_n136# w_n180_n88# 0.09243f
C3 a_94_0# w_n180_n88# 0.00716f
C4 a_n92_0# a_28_n136# 0.00321f
C5 a_n92_0# a_94_0# 0.02488f
C6 a_94_0# VSUBS 0.0369f
C7 a_n92_0# VSUBS 0.0369f
C8 a_28_n136# VSUBS 0.13535f
C9 w_n180_n88# VSUBS 0.40738f
.ends

.subckt pfet$1 a_n92_0# a_28_260# w_n230_n138# VSUBS
X0 w_n230_n138# a_28_260# a_n92_0# w_n230_n138# pfet_03v3 ad=1.38p pd=4.76u as=0.65p ps=3.3u w=1u l=0.28u
C0 a_n92_0# w_n230_n138# 0.0352f
C1 a_28_260# w_n230_n138# 0.14751f
C2 a_n92_0# a_28_260# 0.00351f
C3 a_n92_0# VSUBS 0.03098f
C4 a_28_260# VSUBS 0.08197f
C5 w_n230_n138# VSUBS 1.08986f
.ends

.subckt nfet$4 a_30_n132# a_n84_0# a_94_0# VSUBS
X0 a_94_0# a_30_n132# a_n84_0# VSUBS nfet_03v3 ad=0.305p pd=2.22u as=0.305p ps=2.22u w=0.5u l=0.28u
C0 a_94_0# a_30_n132# 0.00325f
C1 a_n84_0# a_30_n132# 0.00325f
C2 a_94_0# a_n84_0# 0.02606f
C3 a_94_0# VSUBS 0.04417f
C4 a_n84_0# VSUBS 0.04417f
C5 a_30_n132# VSUBS 0.22246f
.ends

.subckt bootstrapped VDD VSS CLK VIN VOUT
Xpfet_0 m2_3352_405# m3_3464_703# w_4010_1117# pfet_0/VSUBS pfet
Xcap_mim_0 m4_2132_331# w_4010_1117# pfet_0/VSUBS cap_mim
Xnfet$5_0 m3_3464_703# VIN VOUT pfet_0/VSUBS nfet$5
Xnfet_0 m2_4436_350# VSS m3_2756_199# pfet_0/VSUBS nfet
Xnfet_1 VSS m2_4436_350# m3_2756_199# pfet_0/VSUBS nfet
Xnfet_2 VSS m3_2756_199# CLK pfet_0/VSUBS nfet
Xnfet_3 m4_2132_331# m2_3352_405# CLK pfet_0/VSUBS nfet
Xnfet_4 m4_2132_331# m2_3352_405# m3_3464_703# pfet_0/VSUBS nfet
Xpfet$3_0 CLK w_2134_1117# VDD m3_2756_199# pfet_0/VSUBS pfet$3
Xnfet_5 m4_2132_331# VIN m3_3464_703# pfet_0/VSUBS nfet
Xpfet$3_1 CLK w_2134_1117# m3_2756_199# VDD pfet_0/VSUBS pfet$3
Xpfet$3_2 CLK w_2134_1117# VDD m2_3352_405# pfet_0/VSUBS pfet$3
Xpfet$1_0 VDD m3_3464_703# w_4010_1117# pfet_0/VSUBS pfet$1
Xpfet$3_3 CLK w_2134_1117# m2_3352_405# VDD pfet_0/VSUBS pfet$3
Xnfet$4_0 VDD m3_3464_703# m2_4436_350# pfet_0/VSUBS nfet$4
Xnfet$4_1 VDD m2_4436_350# m3_3464_703# pfet_0/VSUBS nfet$4
Xnfet$4_2 m3_2756_199# m4_2132_331# VSS pfet_0/VSUBS nfet$4
C0 VIN VSS 0.10218f
C1 m3_3464_703# VOUT 0.01008f
C2 m2_5152_227# m3_3464_703# 0.01423f
C3 m3_3464_703# VDD 0.41281f
C4 m2_4436_350# w_4010_1117# 0.01764f
C5 VDD CLK 0.41204f
C6 m4_2132_331# VSS 0.14104f
C7 m2_3352_405# w_4010_1117# 0.3342f
C8 m2_4436_350# m2_3352_405# 0.00114f
C9 VIN w_4010_1117# 0.0039f
C10 w_2134_1117# m3_2756_199# 0.0366f
C11 VOUT VSS 0.19083f
C12 m2_4436_350# VIN 0.30459f
C13 VDD VSS 0.43867f
C14 m2_5152_227# VSS 0.02074f
C15 VIN m2_3352_405# 0.00477f
C16 m4_2132_331# w_4010_1117# 0.0747f
C17 m3_3464_703# w_2134_1117# 0.0121f
C18 w_2134_1117# CLK 0.34876f
C19 m4_2132_331# m2_4436_350# 0
C20 m4_2132_331# m2_3352_405# 0.10029f
C21 m3_3464_703# m3_2756_199# 0.04832f
C22 m2_5152_227# w_4010_1117# 0.0016f
C23 VDD w_4010_1117# 0.50075f
C24 CLK m3_2756_199# 0.55756f
C25 m2_4436_350# VOUT 0
C26 m4_2132_331# VIN 0.06551f
C27 m2_4436_350# VDD 0.13138f
C28 m2_5152_227# m2_4436_350# 0.00109f
C29 w_2134_1117# VSS 0.0173f
C30 VDD m2_3352_405# 0.39694f
C31 m3_3464_703# CLK 0.0436f
C32 VIN VOUT 0.04806f
C33 m2_5152_227# VIN 0.03414f
C34 VDD VIN 0.02992f
C35 VSS m3_2756_199# 0.78025f
C36 m4_2132_331# VOUT 0
C37 w_2134_1117# w_4010_1117# 0.08046f
C38 m4_2132_331# VDD 0.07167f
C39 m2_5152_227# m4_2132_331# 0
C40 m3_3464_703# VSS 0.64291f
C41 VSS CLK 0.17688f
C42 w_2134_1117# m2_3352_405# 0.06571f
C43 w_4010_1117# m3_2756_199# 0.05232f
C44 VDD VOUT 0
C45 m2_5152_227# VOUT 0.0394f
C46 m2_4436_350# m3_2756_199# 0.09525f
C47 m2_5152_227# VDD 0.00301f
C48 m2_3352_405# m3_2756_199# 0.05855f
C49 m3_3464_703# w_4010_1117# 0.69818f
C50 CLK w_4010_1117# 0.05178f
C51 m2_4436_350# m3_3464_703# 0.05687f
C52 VIN m3_2756_199# 0.40715f
C53 m4_2132_331# w_2134_1117# 0.064f
C54 m2_4436_350# CLK 0
C55 m3_3464_703# m2_3352_405# 0.54367f
C56 m2_3352_405# CLK 0.30321f
C57 m3_3464_703# VIN 0.24862f
C58 m4_2132_331# m3_2756_199# 0.21325f
C59 VIN CLK 0
C60 w_2134_1117# VDD 0.98479f
C61 VSS w_4010_1117# 0.2787f
C62 m2_4436_350# VSS 0.16244f
C63 VOUT m3_2756_199# 0.00102f
C64 m4_2132_331# m3_3464_703# 0.03439f
C65 m4_2132_331# CLK 0.08216f
C66 VSS m2_3352_405# 0.1452f
C67 m2_5152_227# m3_2756_199# 0.00685f
C68 VDD m3_2756_199# 0.12905f
C69 m2_5152_227# pfet_0/VSUBS 0.09542f
C70 w_4010_1117# pfet_0/VSUBS 0.94376f
C71 m4_2132_331# pfet_0/VSUBS -0.29747f
C72 m2_4436_350# pfet_0/VSUBS -0.31564f
C73 w_2134_1117# pfet_0/VSUBS 2.8808f
C74 VDD pfet_0/VSUBS -2.16439f
C75 VIN pfet_0/VSUBS -0.28222f
C76 m3_3464_703# pfet_0/VSUBS -0.64772f
C77 m2_3352_405# pfet_0/VSUBS -0.63853f
C78 m3_2756_199# pfet_0/VSUBS -0.43641f
C79 CLK pfet_0/VSUBS -1.22176f
C80 VOUT pfet_0/VSUBS -0.04032f
C81 VSS pfet_0/VSUBS -1.31997f
.ends
