** sch_path: /foss/designs/Chipathon-2026-OnChipSAR/designs/sar_adc/digital/gate_buf_output/xschem/gate_buf_output.sch
.subckt gate_buf_output VDD VIN VOUT VSS
*.PININFO VDD:B VSS:B VIN:B VOUT:B
MN1 net1 VIN VSS VSS nfet_03v3 L=0.28u W=2u nf=1
MP1 net1 VIN VDD VDD pfet_03v3 L=0.28u W=6u nf=1
MP2 net2 net1 VDD VDD pfet_03v3 L=0.28u W=6u nf=1 m=4
MN2 net2 net1 VSS VSS nfet_03v3 L=0.28u W=2u nf=1 m=4
MP3 VOUT net2 VDD VDD pfet_03v3 L=0.28u W=6u nf=1 m=16
MN3 VOUT net2 VSS VSS nfet_03v3 L=0.28u W=2u nf=1 m=16
.ends
