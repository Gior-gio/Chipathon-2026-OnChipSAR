** sch_path: /foss/designs/Chipathon-2026-OnChipSAR/designs/sar_adc/digital/digital_logic/lvs_v0.sch
.subckt lvs_v0 D G S
*.PININFO D:B S:B G:B
M1 D G S S nfet_03v3 L=0.5u W=0.5u nf=1
.ends
