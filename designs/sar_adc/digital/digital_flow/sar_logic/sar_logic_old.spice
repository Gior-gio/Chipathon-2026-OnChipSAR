* NGSPICE file created from sar_logic.ext - technology: gf180mcuD

* Black-box entry subcircuit for gf180mcu_fd_sc_mcu7t5v0__fill_1 abstract view
.subckt gf180mcu_fd_sc_mcu7t5v0__fill_1 VDD VNW VPW VSS
.ends

* Black-box entry subcircuit for gf180mcu_fd_sc_mcu7t5v0__fill_2 abstract view
.subckt gf180mcu_fd_sc_mcu7t5v0__fill_2 VDD VNW VPW VSS
.ends

* Black-box entry subcircuit for gf180mcu_fd_sc_mcu7t5v0__dffrsnq_2 abstract view
.subckt gf180mcu_fd_sc_mcu7t5v0__dffrsnq_2 D RN SETN CLK Q VDD VNW VPW VSS
.ends

* Black-box entry subcircuit for gf180mcu_fd_sc_mcu7t5v0__clkinv_1 abstract view
.subckt gf180mcu_fd_sc_mcu7t5v0__clkinv_1 I ZN VDD VNW VPW VSS
.ends

* Black-box entry subcircuit for gf180mcu_fd_sc_mcu7t5v0__tieh abstract view
.subckt gf180mcu_fd_sc_mcu7t5v0__tieh Z VDD VNW VPW VSS
.ends

* Black-box entry subcircuit for gf180mcu_fd_sc_mcu7t5v0__or2_1 abstract view
.subckt gf180mcu_fd_sc_mcu7t5v0__or2_1 A1 A2 Z VDD VNW VPW VSS
.ends

* Black-box entry subcircuit for gf180mcu_fd_sc_mcu7t5v0__filltie abstract view
.subckt gf180mcu_fd_sc_mcu7t5v0__filltie VDD VSS
.ends

* Black-box entry subcircuit for gf180mcu_fd_sc_mcu7t5v0__clkbuf_1 abstract view
.subckt gf180mcu_fd_sc_mcu7t5v0__clkbuf_1 I Z VDD VNW VPW VSS
.ends

* Black-box entry subcircuit for gf180mcu_fd_sc_mcu7t5v0__buf_1 abstract view
.subckt gf180mcu_fd_sc_mcu7t5v0__buf_1 I Z VDD VNW VPW VSS
.ends

* Black-box entry subcircuit for gf180mcu_fd_sc_mcu7t5v0__endcap abstract view
.subckt gf180mcu_fd_sc_mcu7t5v0__endcap VDD VSS
.ends

* Black-box entry subcircuit for gf180mcu_fd_sc_mcu7t5v0__fillcap_8 abstract view
.subckt gf180mcu_fd_sc_mcu7t5v0__fillcap_8 VDD VNW VPW VSS
.ends

* Black-box entry subcircuit for gf180mcu_fd_sc_mcu7t5v0__fillcap_4 abstract view
.subckt gf180mcu_fd_sc_mcu7t5v0__fillcap_4 VDD VNW VPW VSS
.ends

* Black-box entry subcircuit for gf180mcu_fd_sc_mcu7t5v0__buf_4 abstract view
.subckt gf180mcu_fd_sc_mcu7t5v0__buf_4 I Z VDD VNW VPW VSS
.ends

* Black-box entry subcircuit for gf180mcu_fd_sc_mcu7t5v0__dlyc_1 abstract view
.subckt gf180mcu_fd_sc_mcu7t5v0__dlyc_1 I Z VDD VNW VPW VSS
.ends

* Black-box entry subcircuit for gf180mcu_fd_sc_mcu7t5v0__fillcap_32 abstract view
.subckt gf180mcu_fd_sc_mcu7t5v0__fillcap_32 VDD VNW VPW VSS
.ends

* Black-box entry subcircuit for gf180mcu_fd_sc_mcu7t5v0__inv_2 abstract view
.subckt gf180mcu_fd_sc_mcu7t5v0__inv_2 I ZN VDD VNW VPW VSS
.ends

* Black-box entry subcircuit for gf180mcu_fd_sc_mcu7t5v0__clkbuf_16 abstract view
.subckt gf180mcu_fd_sc_mcu7t5v0__clkbuf_16 I Z VDD VNW VPW VSS
.ends

* Black-box entry subcircuit for gf180mcu_fd_sc_mcu7t5v0__nand2_1 abstract view
.subckt gf180mcu_fd_sc_mcu7t5v0__nand2_1 A1 A2 ZN VDD VNW VPW VSS
.ends

* Black-box entry subcircuit for gf180mcu_fd_sc_mcu7t5v0__mux2_2 abstract view
.subckt gf180mcu_fd_sc_mcu7t5v0__mux2_2 I0 I1 S Z VDD VNW VPW VSS
.ends

* Black-box entry subcircuit for gf180mcu_fd_sc_mcu7t5v0__buf_2 abstract view
.subckt gf180mcu_fd_sc_mcu7t5v0__buf_2 I Z VDD VNW VPW VSS
.ends

* Black-box entry subcircuit for gf180mcu_fd_sc_mcu7t5v0__nor2_1 abstract view
.subckt gf180mcu_fd_sc_mcu7t5v0__nor2_1 A1 A2 ZN VDD VNW VPW VSS
.ends

* Black-box entry subcircuit for gf180mcu_fd_sc_mcu7t5v0__buf_3 abstract view
.subckt gf180mcu_fd_sc_mcu7t5v0__buf_3 I Z VDD VNW VPW VSS
.ends

* Black-box entry subcircuit for gf180mcu_fd_sc_mcu7t5v0__dffrnq_1 abstract view
.subckt gf180mcu_fd_sc_mcu7t5v0__dffrnq_1 D RN CLK Q VDD VNW VPW VSS
.ends

* Black-box entry subcircuit for gf180mcu_fd_sc_mcu7t5v0__dffrnq_2 abstract view
.subckt gf180mcu_fd_sc_mcu7t5v0__dffrnq_2 D RN CLK Q VDD VNW VPW VSS
.ends

* Black-box entry subcircuit for gf180mcu_fd_sc_mcu7t5v0__dlyb_1 abstract view
.subckt gf180mcu_fd_sc_mcu7t5v0__dlyb_1 I Z VDD VNW VPW VSS
.ends

* Black-box entry subcircuit for gf180mcu_fd_sc_mcu7t5v0__fillcap_16 abstract view
.subckt gf180mcu_fd_sc_mcu7t5v0__fillcap_16 VDD VNW VPW VSS
.ends

* Black-box entry subcircuit for gf180mcu_fd_sc_mcu7t5v0__dffrsnq_1 abstract view
.subckt gf180mcu_fd_sc_mcu7t5v0__dffrsnq_1 D RN SETN CLK Q VDD VNW VPW VSS
.ends

.subckt sar_logic B[0] B[1] B[2] B[3] B[4] B[5] B[6] B[7] B[8] B[9] CLK SAMP SW0n[0]
+ SW0n[1] SW0n[2] SW0n[3] SW0n[4] SW0n[5] SW0n[6] SW0n[7] SW0n[8] SW0p[0] SW0p[1]
+ SW0p[2] SW0p[3] SW0p[4] SW0p[5] SW0p[6] SW0p[7] SW0p[8] SW1n[0] SW1n[1] SW1n[2]
+ SW1n[3] SW1n[4] SW1n[5] SW1n[6] SW1n[7] SW1n[8] SW1p[0] SW1p[1] SW1p[2] SW1p[3]
+ SW1p[4] SW1p[5] SW1p[6] SW1p[7] SW1p[8] VDD VSS Vcomp eoc
XFILLER_13_199 VDD VDD VSS VSS gf180mcu_fd_sc_mcu7t5v0__fill_1
XFILLER_13_144 VDD VDD VSS VSS gf180mcu_fd_sc_mcu7t5v0__fill_1
XFILLER_6_107 VDD VDD VSS VSS gf180mcu_fd_sc_mcu7t5v0__fill_2
X_131_ _131_/D _131_/RN _119_/Z _142_/CLK _154_/I VDD VDD VSS VSS gf180mcu_fd_sc_mcu7t5v0__dffrsnq_2
X_062_ _062_/I _062_/ZN VDD VDD VSS VSS gf180mcu_fd_sc_mcu7t5v0__clkinv_1
X_143__86 _143_/D VDD VDD VSS VSS gf180mcu_fd_sc_mcu7t5v0__tieh
X_114_ _122_/I wire55/I _114_/Z VDD VDD VSS VSS gf180mcu_fd_sc_mcu7t5v0__or2_1
XTAP_TAPCELL_ROW_5_45 VDD VSS gf180mcu_fd_sc_mcu7t5v0__filltie
Xoutput20 wire77/Z SW0n[7] VDD VDD VSS VSS gf180mcu_fd_sc_mcu7t5v0__clkbuf_1
Xoutput31 _163_/Z SW1n[0] VDD VDD VSS VSS gf180mcu_fd_sc_mcu7t5v0__buf_1
Xoutput42 _174_/Z SW1p[2] VDD VDD VSS VSS gf180mcu_fd_sc_mcu7t5v0__buf_1
Xoutput7 _062_/ZN B[4] VDD VDD VSS VSS gf180mcu_fd_sc_mcu7t5v0__buf_1
XFILLER_10_104 VDD VDD VSS VSS gf180mcu_fd_sc_mcu7t5v0__fill_1
X_130_ _130_/D _130_/RN _118_/Z _143_/CLK _155_/I VDD VDD VSS VSS gf180mcu_fd_sc_mcu7t5v0__dffrsnq_2
XPHY_EDGE_ROW_12_Right_12 VDD VSS gf180mcu_fd_sc_mcu7t5v0__endcap
XFILLER_0_36 VDD VDD VSS VSS gf180mcu_fd_sc_mcu7t5v0__fillcap_8
X_061_ _061_/I _061_/ZN VDD VDD VSS VSS gf180mcu_fd_sc_mcu7t5v0__clkinv_1
XFILLER_9_89 VDD VDD VSS VSS gf180mcu_fd_sc_mcu7t5v0__fill_1
XFILLER_3_2 VDD VDD VSS VSS gf180mcu_fd_sc_mcu7t5v0__fillcap_4
X_113_ _109_/I wire55/I _113_/Z VDD VDD VSS VSS gf180mcu_fd_sc_mcu7t5v0__or2_1
XTAP_TAPCELL_ROW_5_46 VDD VSS gf180mcu_fd_sc_mcu7t5v0__filltie
XPHY_EDGE_ROW_6_Right_6 VDD VSS gf180mcu_fd_sc_mcu7t5v0__endcap
Xoutput10 _065_/ZN B[7] VDD VDD VSS VSS gf180mcu_fd_sc_mcu7t5v0__buf_1
Xoutput21 _092_/I1 SW0n[8] VDD VDD VSS VSS gf180mcu_fd_sc_mcu7t5v0__clkbuf_1
Xoutput32 _164_/Z SW1n[1] VDD VDD VSS VSS gf180mcu_fd_sc_mcu7t5v0__buf_4
Xoutput43 _175_/Z SW1p[3] VDD VDD VSS VSS gf180mcu_fd_sc_mcu7t5v0__buf_4
Xoutput8 _063_/ZN B[5] VDD VDD VSS VSS gf180mcu_fd_sc_mcu7t5v0__buf_1
XFILLER_13_179 VDD VDD VSS VSS gf180mcu_fd_sc_mcu7t5v0__fill_2
XFILLER_3_69 VDD VDD VSS VSS gf180mcu_fd_sc_mcu7t5v0__fill_1
XFILLER_12_34 VDD VDD VSS VSS gf180mcu_fd_sc_mcu7t5v0__fill_1
XFILLER_10_138 VDD VDD VSS VSS gf180mcu_fd_sc_mcu7t5v0__fill_1
XFILLER_0_48 VDD VDD VSS VSS gf180mcu_fd_sc_mcu7t5v0__fill_2
X_060_ _060_/I _060_/ZN VDD VDD VSS VSS gf180mcu_fd_sc_mcu7t5v0__clkinv_1
X_112_ _109_/I _142_/D _112_/Z VDD VDD VSS VSS gf180mcu_fd_sc_mcu7t5v0__or2_1
XPHY_EDGE_ROW_12_Left_27 VDD VSS gf180mcu_fd_sc_mcu7t5v0__endcap
Xhold87 SAMP input1/I VDD VDD VSS VSS gf180mcu_fd_sc_mcu7t5v0__dlyc_1
XFILLER_6_25 VDD VDD VSS VSS gf180mcu_fd_sc_mcu7t5v0__fill_2
Xoutput11 _066_/ZN B[8] VDD VDD VSS VSS gf180mcu_fd_sc_mcu7t5v0__buf_1
Xoutput22 _154_/Z SW0p[0] VDD VDD VSS VSS gf180mcu_fd_sc_mcu7t5v0__buf_4
Xoutput33 _069_/I SW1n[2] VDD VDD VSS VSS gf180mcu_fd_sc_mcu7t5v0__buf_1
Xoutput44 _070_/I SW1p[4] VDD VDD VSS VSS gf180mcu_fd_sc_mcu7t5v0__clkbuf_1
Xoutput9 _064_/ZN B[6] VDD VDD VSS VSS gf180mcu_fd_sc_mcu7t5v0__buf_1
XTAP_TAPCELL_ROW_2_37 VDD VSS gf180mcu_fd_sc_mcu7t5v0__filltie
XFILLER_8_195 VDD VDD VSS VSS gf180mcu_fd_sc_mcu7t5v0__fillcap_4
XPHY_EDGE_ROW_0_Left_15 VDD VSS gf180mcu_fd_sc_mcu7t5v0__endcap
XFILLER_9_47 VDD VDD VSS VSS gf180mcu_fd_sc_mcu7t5v0__fillcap_4
X_111_ _122_/I _143_/RN VDD VDD VSS VSS gf180mcu_fd_sc_mcu7t5v0__clkinv_1
XFILLER_6_37 VDD VDD VSS VSS gf180mcu_fd_sc_mcu7t5v0__fill_1
XFILLER_13_6 VDD VDD VSS VSS gf180mcu_fd_sc_mcu7t5v0__fill_1
Xoutput12 _067_/ZN B[9] VDD VDD VSS VSS gf180mcu_fd_sc_mcu7t5v0__buf_1
Xoutput23 _155_/Z SW0p[1] VDD VDD VSS VSS gf180mcu_fd_sc_mcu7t5v0__buf_4
Xoutput34 _166_/Z SW1n[3] VDD VDD VSS VSS gf180mcu_fd_sc_mcu7t5v0__buf_1
Xoutput45 _085_/A1 SW1p[5] VDD VDD VSS VSS gf180mcu_fd_sc_mcu7t5v0__clkbuf_1
XTAP_TAPCELL_ROW_2_38 VDD VSS gf180mcu_fd_sc_mcu7t5v0__filltie
XFILLER_12_25 VDD VDD VSS VSS gf180mcu_fd_sc_mcu7t5v0__fill_1
XFILLER_10_107 VDD VDD VSS VSS gf180mcu_fd_sc_mcu7t5v0__fill_2
XFILLER_9_15 VDD VDD VSS VSS gf180mcu_fd_sc_mcu7t5v0__fillcap_32
XFILLER_1_180 VDD VDD VSS VSS gf180mcu_fd_sc_mcu7t5v0__fill_1
Xclkload0 _142_/CLK clkload0/ZN VDD VDD VSS VSS gf180mcu_fd_sc_mcu7t5v0__inv_2
X_110_ _110_/I _142_/RN VDD VDD VSS VSS gf180mcu_fd_sc_mcu7t5v0__clkinv_1
XFILLER_1_2 VDD VDD VSS VSS gf180mcu_fd_sc_mcu7t5v0__fillcap_4
Xoutput13 _059_/I SW0n[0] VDD VDD VSS VSS gf180mcu_fd_sc_mcu7t5v0__clkbuf_1
Xoutput24 _156_/Z SW0p[2] VDD VDD VSS VSS gf180mcu_fd_sc_mcu7t5v0__buf_4
Xoutput35 _167_/Z SW1n[4] VDD VDD VSS VSS gf180mcu_fd_sc_mcu7t5v0__buf_1
Xoutput46 _071_/I SW1p[6] VDD VDD VSS VSS gf180mcu_fd_sc_mcu7t5v0__clkbuf_1
XTAP_TAPCELL_ROW_2_39 VDD VSS gf180mcu_fd_sc_mcu7t5v0__filltie
Xclkbuf_1_1__f_CLK clkbuf_0_CLK/Z _142_/CLK VDD VDD VSS VSS gf180mcu_fd_sc_mcu7t5v0__clkbuf_16
XFILLER_3_6 VDD VDD VSS VSS gf180mcu_fd_sc_mcu7t5v0__fill_1
XFILLER_2_159 VDD VDD VSS VSS gf180mcu_fd_sc_mcu7t5v0__fill_2
XFILLER_2_115 VDD VDD VSS VSS gf180mcu_fd_sc_mcu7t5v0__fill_2
X_169_ _169_/I _169_/Z VDD VDD VSS VSS gf180mcu_fd_sc_mcu7t5v0__buf_4
XFILLER_1_72 VDD VDD VSS VSS gf180mcu_fd_sc_mcu7t5v0__fillcap_4
Xoutput14 _060_/I SW0n[1] VDD VDD VSS VSS gf180mcu_fd_sc_mcu7t5v0__clkbuf_1
Xoutput25 _157_/Z SW0p[3] VDD VDD VSS VSS gf180mcu_fd_sc_mcu7t5v0__buf_4
Xoutput36 _168_/Z SW1n[5] VDD VDD VSS VSS gf180mcu_fd_sc_mcu7t5v0__buf_1
Xoutput47 _089_/A1 SW1p[7] VDD VDD VSS VSS gf180mcu_fd_sc_mcu7t5v0__clkbuf_1
XFILLER_13_139 VDD VDD VSS VSS gf180mcu_fd_sc_mcu7t5v0__fill_1
XFILLER_12_183 VDD VDD VSS VSS gf180mcu_fd_sc_mcu7t5v0__fill_2
XPHY_EDGE_ROW_4_Left_19 VDD VSS gf180mcu_fd_sc_mcu7t5v0__endcap
X_168_ _168_/I _168_/Z VDD VDD VSS VSS gf180mcu_fd_sc_mcu7t5v0__buf_4
X_099_ _122_/I _126_/RN VDD VDD VSS VSS gf180mcu_fd_sc_mcu7t5v0__clkinv_1
XFILLER_1_62 VDD VDD VSS VSS gf180mcu_fd_sc_mcu7t5v0__fillcap_8
XPHY_EDGE_ROW_7_Left_22 VDD VSS gf180mcu_fd_sc_mcu7t5v0__endcap
Xoutput15 _061_/I SW0n[2] VDD VDD VSS VSS gf180mcu_fd_sc_mcu7t5v0__clkbuf_1
Xoutput26 _158_/Z SW0p[4] VDD VDD VSS VSS gf180mcu_fd_sc_mcu7t5v0__buf_4
Xoutput37 _169_/Z SW1n[6] VDD VDD VSS VSS gf180mcu_fd_sc_mcu7t5v0__buf_1
Xoutput48 _180_/Z SW1p[8] VDD VDD VSS VSS gf180mcu_fd_sc_mcu7t5v0__buf_1
XPHY_EDGE_ROW_1_Right_1 VDD VSS gf180mcu_fd_sc_mcu7t5v0__endcap
XTAP_TAPCELL_ROW_3_40 VDD VSS gf180mcu_fd_sc_mcu7t5v0__filltie
XFILLER_8_199 VDD VDD VSS VSS gf180mcu_fd_sc_mcu7t5v0__fill_1
XFILLER_2_117 VDD VDD VSS VSS gf180mcu_fd_sc_mcu7t5v0__fill_1
XTAP_TAPCELL_ROW_0_30 VDD VSS gf180mcu_fd_sc_mcu7t5v0__filltie
X_167_ _167_/I _167_/Z VDD VDD VSS VSS gf180mcu_fd_sc_mcu7t5v0__buf_4
X_098_ _121_/I _127_/RN VDD VDD VSS VSS gf180mcu_fd_sc_mcu7t5v0__clkinv_1
Xoutput16 _062_/I SW0n[3] VDD VDD VSS VSS gf180mcu_fd_sc_mcu7t5v0__clkbuf_1
Xoutput27 _159_/Z SW0p[5] VDD VDD VSS VSS gf180mcu_fd_sc_mcu7t5v0__buf_4
Xoutput38 _170_/Z SW1n[7] VDD VDD VSS VSS gf180mcu_fd_sc_mcu7t5v0__buf_4
Xoutput49 _133_/Q eoc VDD VDD VSS VSS gf180mcu_fd_sc_mcu7t5v0__buf_1
Xmax_cap80 _088_/I0 _086_/I1 VDD VDD VSS VSS gf180mcu_fd_sc_mcu7t5v0__clkbuf_1
XTAP_TAPCELL_ROW_3_41 VDD VSS gf180mcu_fd_sc_mcu7t5v0__filltie
XFILLER_12_185 VDD VDD VSS VSS gf180mcu_fd_sc_mcu7t5v0__fill_1
XFILLER_4_41 VDD VDD VSS VSS gf180mcu_fd_sc_mcu7t5v0__fill_1
XTAP_TAPCELL_ROW_0_31 VDD VSS gf180mcu_fd_sc_mcu7t5v0__filltie
XFILLER_13_72 VDD VDD VSS VSS gf180mcu_fd_sc_mcu7t5v0__fill_2
XFILLER_1_6 VDD VDD VSS VSS gf180mcu_fd_sc_mcu7t5v0__fill_1
X_166_ _166_/I _166_/Z VDD VDD VSS VSS gf180mcu_fd_sc_mcu7t5v0__buf_1
X_097_ _121_/I _128_/RN VDD VDD VSS VSS gf180mcu_fd_sc_mcu7t5v0__clkinv_1
Xoutput17 _063_/I SW0n[4] VDD VDD VSS VSS gf180mcu_fd_sc_mcu7t5v0__clkbuf_1
Xoutput28 _160_/Z SW0p[6] VDD VDD VSS VSS gf180mcu_fd_sc_mcu7t5v0__buf_4
Xoutput39 _171_/Z SW1n[8] VDD VDD VSS VSS gf180mcu_fd_sc_mcu7t5v0__buf_4
Xmax_cap70 _154_/I _059_/I VDD VDD VSS VSS gf180mcu_fd_sc_mcu7t5v0__buf_4
Xmax_cap81 wire82/Z _088_/I0 VDD VDD VSS VSS gf180mcu_fd_sc_mcu7t5v0__clkbuf_1
XTAP_TAPCELL_ROW_0_32 VDD VSS gf180mcu_fd_sc_mcu7t5v0__filltie
X_096_ _122_/I _129_/RN VDD VDD VSS VSS gf180mcu_fd_sc_mcu7t5v0__clkinv_1
XFILLER_1_98 VDD VDD VSS VSS gf180mcu_fd_sc_mcu7t5v0__fill_1
XFILLER_1_76 VDD VDD VSS VSS gf180mcu_fd_sc_mcu7t5v0__fill_2
XFILLER_1_21 VDD VDD VSS VSS gf180mcu_fd_sc_mcu7t5v0__fillcap_4
Xoutput18 _086_/I0 SW0n[5] VDD VDD VSS VSS gf180mcu_fd_sc_mcu7t5v0__clkbuf_1
Xoutput29 _161_/Z SW0p[7] VDD VDD VSS VSS gf180mcu_fd_sc_mcu7t5v0__buf_4
X_079_ _079_/A1 _175_/I _080_/S VDD VDD VSS VSS gf180mcu_fd_sc_mcu7t5v0__nand2_1
Xmax_cap60 _141_/Q _170_/I VDD VDD VSS VSS gf180mcu_fd_sc_mcu7t5v0__buf_4
XFILLER_7_20 VDD VDD VSS VSS gf180mcu_fd_sc_mcu7t5v0__fillcap_4
XPHY_EDGE_ROW_5_Right_5 VDD VSS gf180mcu_fd_sc_mcu7t5v0__endcap
XTAP_TAPCELL_ROW_0_33 VDD VSS gf180mcu_fd_sc_mcu7t5v0__filltie
XFILLER_13_74 VDD VDD VSS VSS gf180mcu_fd_sc_mcu7t5v0__fill_1
X_164_ _164_/I _164_/Z VDD VDD VSS VSS gf180mcu_fd_sc_mcu7t5v0__buf_4
X_095_ _122_/I _130_/RN VDD VDD VSS VSS gf180mcu_fd_sc_mcu7t5v0__clkinv_1
X_078_ _060_/I _086_/I1 _078_/S _130_/D VDD VDD VSS VSS gf180mcu_fd_sc_mcu7t5v0__mux2_2
XPHY_EDGE_ROW_11_Left_26 VDD VSS gf180mcu_fd_sc_mcu7t5v0__endcap
Xoutput19 _088_/I1 SW0n[6] VDD VDD VSS VSS gf180mcu_fd_sc_mcu7t5v0__clkbuf_1
Xmax_cap61 _169_/I _071_/I VDD VDD VSS VSS gf180mcu_fd_sc_mcu7t5v0__buf_4
Xmax_cap83 _109_/I _122_/I VDD VDD VSS VSS gf180mcu_fd_sc_mcu7t5v0__buf_2
XPHY_EDGE_ROW_11_Right_11 VDD VSS gf180mcu_fd_sc_mcu7t5v0__endcap
X_180_ _180_/I _180_/Z VDD VDD VSS VSS gf180mcu_fd_sc_mcu7t5v0__clkbuf_1
XTAP_TAPCELL_ROW_0_34 VDD VSS gf180mcu_fd_sc_mcu7t5v0__filltie
XFILLER_8_2 VDD VDD VSS VSS gf180mcu_fd_sc_mcu7t5v0__fillcap_4
X_163_ _163_/I _163_/Z VDD VDD VSS VSS gf180mcu_fd_sc_mcu7t5v0__buf_1
X_094_ _121_/I _131_/RN VDD VDD VSS VSS gf180mcu_fd_sc_mcu7t5v0__clkinv_1
XFILLER_1_78 VDD VDD VSS VSS gf180mcu_fd_sc_mcu7t5v0__fill_1
XFILLER_10_32 VDD VDD VSS VSS gf180mcu_fd_sc_mcu7t5v0__fill_2
X_077_ _164_/I _079_/A1 wire53/I VDD VDD VSS VSS gf180mcu_fd_sc_mcu7t5v0__nor2_1
Xmax_cap84 _121_/I _109_/I VDD VDD VSS VSS gf180mcu_fd_sc_mcu7t5v0__buf_4
X_129_ _129_/D _129_/RN _117_/Z _143_/CLK _156_/I VDD VDD VSS VSS gf180mcu_fd_sc_mcu7t5v0__dffrsnq_2
XFILLER_4_174 VDD VDD VSS VSS gf180mcu_fd_sc_mcu7t5v0__fill_1
XTAP_TAPCELL_ROW_13_65 VDD VSS gf180mcu_fd_sc_mcu7t5v0__filltie
XTAP_TAPCELL_ROW_9_55 VDD VSS gf180mcu_fd_sc_mcu7t5v0__filltie
XFILLER_1_199 VDD VDD VSS VSS gf180mcu_fd_sc_mcu7t5v0__fill_1
X_162_ _162_/I _162_/Z VDD VDD VSS VSS gf180mcu_fd_sc_mcu7t5v0__buf_4
X_093_ _109_/I _142_/D _093_/Z VDD VDD VSS VSS gf180mcu_fd_sc_mcu7t5v0__or2_1
Xinput1 input1/I _110_/I VDD VDD VSS VSS gf180mcu_fd_sc_mcu7t5v0__buf_3
XFILLER_10_55 VDD VDD VSS VSS gf180mcu_fd_sc_mcu7t5v0__fill_2
X_076_ _082_/I1 _154_/I _076_/S _131_/D VDD VDD VSS VSS gf180mcu_fd_sc_mcu7t5v0__mux2_2
Xmax_cap63 _168_/I _085_/A1 VDD VDD VSS VSS gf180mcu_fd_sc_mcu7t5v0__buf_4
Xmax_cap74 _158_/I _063_/I VDD VDD VSS VSS gf180mcu_fd_sc_mcu7t5v0__buf_4
Xmax_cap85 _110_/I _121_/I VDD VDD VSS VSS gf180mcu_fd_sc_mcu7t5v0__buf_2
X_128_ _128_/D _128_/RN _116_/Z _142_/CLK _157_/I VDD VDD VSS VSS gf180mcu_fd_sc_mcu7t5v0__dffrsnq_2
X_059_ _059_/I _059_/ZN VDD VDD VSS VSS gf180mcu_fd_sc_mcu7t5v0__clkinv_1
XFILLER_12_113 VDD VDD VSS VSS gf180mcu_fd_sc_mcu7t5v0__fill_1
XPHY_EDGE_ROW_9_Right_9 VDD VSS gf180mcu_fd_sc_mcu7t5v0__endcap
XTAP_TAPCELL_ROW_13_66 VDD VSS gf180mcu_fd_sc_mcu7t5v0__filltie
XTAP_TAPCELL_ROW_9_56 VDD VSS gf180mcu_fd_sc_mcu7t5v0__filltie
XFILLER_1_178 VDD VDD VSS VSS gf180mcu_fd_sc_mcu7t5v0__fill_2
X_161_ _161_/I _161_/Z VDD VDD VSS VSS gf180mcu_fd_sc_mcu7t5v0__buf_4
X_092_ wire82/I _092_/I1 _092_/S _123_/D VDD VDD VSS VSS gf180mcu_fd_sc_mcu7t5v0__mux2_2
XFILLER_1_25 VDD VDD VSS VSS gf180mcu_fd_sc_mcu7t5v0__fill_1
Xinput2 Vcomp wire82/I VDD VDD VSS VSS gf180mcu_fd_sc_mcu7t5v0__buf_1
XFILLER_10_45 VDD VDD VSS VSS gf180mcu_fd_sc_mcu7t5v0__fillcap_4
XFILLER_10_34 VDD VDD VSS VSS gf180mcu_fd_sc_mcu7t5v0__fill_1
X_075_ _075_/A1 _173_/I _076_/S VDD VDD VSS VSS gf180mcu_fd_sc_mcu7t5v0__nand2_1
Xmax_cap64 _167_/I _070_/I VDD VDD VSS VSS gf180mcu_fd_sc_mcu7t5v0__buf_4
Xmax_cap75 _159_/I _086_/I0 VDD VDD VSS VSS gf180mcu_fd_sc_mcu7t5v0__buf_4
X_127_ _127_/D _127_/RN _115_/Z _142_/CLK _158_/I VDD VDD VSS VSS gf180mcu_fd_sc_mcu7t5v0__dffrsnq_2
X_058_ _132_/Q _058_/ZN VDD VDD VSS VSS gf180mcu_fd_sc_mcu7t5v0__clkinv_1
XFILLER_7_24 VDD VDD VSS VSS gf180mcu_fd_sc_mcu7t5v0__fill_1
XPHY_EDGE_ROW_3_Left_18 VDD VSS gf180mcu_fd_sc_mcu7t5v0__endcap
X_160_ _160_/I _160_/Z VDD VDD VSS VSS gf180mcu_fd_sc_mcu7t5v0__buf_4
X_091_ _091_/A1 _142_/D _092_/S VDD VDD VSS VSS gf180mcu_fd_sc_mcu7t5v0__nand2_1
XFILLER_6_2 VDD VDD VSS VSS gf180mcu_fd_sc_mcu7t5v0__fillcap_4
XTAP_TAPCELL_ROW_10_57 VDD VSS gf180mcu_fd_sc_mcu7t5v0__filltie
X_143_ _143_/D _143_/RN _143_/CLK _143_/Q VDD VDD VSS VSS gf180mcu_fd_sc_mcu7t5v0__dffrnq_1
X_074_ _132_/Q _082_/I1 _074_/S _132_/D VDD VDD VSS VSS gf180mcu_fd_sc_mcu7t5v0__mux2_2
XTAP_TAPCELL_ROW_6_47 VDD VSS gf180mcu_fd_sc_mcu7t5v0__filltie
XFILLER_10_24 VDD VDD VSS VSS gf180mcu_fd_sc_mcu7t5v0__fillcap_8
Xmax_cap76 _160_/I _088_/I1 VDD VDD VSS VSS gf180mcu_fd_sc_mcu7t5v0__buf_4
X_126_ _126_/D _126_/RN _114_/Z _143_/CLK _159_/I VDD VDD VSS VSS gf180mcu_fd_sc_mcu7t5v0__dffrsnq_2
X_057_ _122_/I _132_/RN VDD VDD VSS VSS gf180mcu_fd_sc_mcu7t5v0__clkinv_1
XPHY_EDGE_ROW_6_Left_21 VDD VSS gf180mcu_fd_sc_mcu7t5v0__endcap
XPHY_EDGE_ROW_0_Right_0 VDD VSS gf180mcu_fd_sc_mcu7t5v0__endcap
XFILLER_12_104 VDD VDD VSS VSS gf180mcu_fd_sc_mcu7t5v0__fill_1
X_109_ _109_/I _141_/RN VDD VDD VSS VSS gf180mcu_fd_sc_mcu7t5v0__clkinv_1
XFILLER_4_37 VDD VDD VSS VSS gf180mcu_fd_sc_mcu7t5v0__fillcap_4
XFILLER_4_177 VDD VDD VSS VSS gf180mcu_fd_sc_mcu7t5v0__fill_2
XFILLER_8_6 VDD VDD VSS VSS gf180mcu_fd_sc_mcu7t5v0__fill_1
X_090_ wire77/Z wire82/Z _090_/S _124_/D VDD VDD VSS VSS gf180mcu_fd_sc_mcu7t5v0__mux2_2
XTAP_TAPCELL_ROW_10_58 VDD VSS gf180mcu_fd_sc_mcu7t5v0__filltie
X_142_ _142_/D _142_/RN _142_/CLK _180_/I VDD VDD VSS VSS gf180mcu_fd_sc_mcu7t5v0__dffrnq_2
XTAP_TAPCELL_ROW_6_48 VDD VSS gf180mcu_fd_sc_mcu7t5v0__filltie
X_073_ _075_/A1 _133_/Q wire54/I VDD VDD VSS VSS gf180mcu_fd_sc_mcu7t5v0__nor2_1
Xmax_cap66 _166_/I _175_/I VDD VDD VSS VSS gf180mcu_fd_sc_mcu7t5v0__buf_4
X_125_ _125_/D _125_/RN _113_/Z _143_/CLK _160_/I VDD VDD VSS VSS gf180mcu_fd_sc_mcu7t5v0__dffrsnq_2
X_108_ _109_/I _140_/RN VDD VDD VSS VSS gf180mcu_fd_sc_mcu7t5v0__clkinv_1
XTAP_TAPCELL_ROW_10_59 VDD VSS gf180mcu_fd_sc_mcu7t5v0__filltie
XFILLER_10_37 VDD VDD VSS VSS gf180mcu_fd_sc_mcu7t5v0__fillcap_8
X_141_ _171_/I _141_/RN _143_/CLK _141_/Q VDD VDD VSS VSS gf180mcu_fd_sc_mcu7t5v0__dffrnq_2
X_072_ _180_/I _091_/A1 VDD VDD VSS VSS gf180mcu_fd_sc_mcu7t5v0__clkinv_1
XTAP_TAPCELL_ROW_6_49 VDD VSS gf180mcu_fd_sc_mcu7t5v0__filltie
Xmax_cap56 wire55/I _119_/A2 VDD VDD VSS VSS gf180mcu_fd_sc_mcu7t5v0__clkbuf_1
Xmax_cap67 _174_/I _069_/I VDD VDD VSS VSS gf180mcu_fd_sc_mcu7t5v0__buf_4
Xmax_cap78 _162_/I _092_/I1 VDD VDD VSS VSS gf180mcu_fd_sc_mcu7t5v0__buf_4
X_124_ _124_/D _124_/RN _112_/Z _142_/CLK _161_/I VDD VDD VSS VSS gf180mcu_fd_sc_mcu7t5v0__dffrsnq_2
X_107_ _109_/I _139_/RN VDD VDD VSS VSS gf180mcu_fd_sc_mcu7t5v0__clkinv_1
XFILLER_4_179 VDD VDD VSS VSS gf180mcu_fd_sc_mcu7t5v0__fill_1
XFILLER_10_49 VDD VDD VSS VSS gf180mcu_fd_sc_mcu7t5v0__fill_2
X_140_ _170_/I _140_/RN _143_/CLK _169_/I VDD VDD VSS VSS gf180mcu_fd_sc_mcu7t5v0__dffrnq_2
X_071_ _071_/I _087_/A1 VDD VDD VSS VSS gf180mcu_fd_sc_mcu7t5v0__clkinv_1
XPHY_EDGE_ROW_14_Right_14 VDD VSS gf180mcu_fd_sc_mcu7t5v0__endcap
XFILLER_4_2 VDD VDD VSS VSS gf180mcu_fd_sc_mcu7t5v0__fillcap_4
Xmax_cap57 _143_/Q wire55/I VDD VDD VSS VSS gf180mcu_fd_sc_mcu7t5v0__clkbuf_1
Xmax_cap79 wire82/Z _082_/I1 VDD VDD VSS VSS gf180mcu_fd_sc_mcu7t5v0__clkbuf_1
X_123_ _123_/D _123_/RN _093_/Z _142_/CLK _162_/I VDD VDD VSS VSS gf180mcu_fd_sc_mcu7t5v0__dffrsnq_2
XFILLER_11_92 VDD VDD VSS VSS gf180mcu_fd_sc_mcu7t5v0__fill_2
X_106_ _109_/I _138_/RN VDD VDD VSS VSS gf180mcu_fd_sc_mcu7t5v0__clkinv_1
XFILLER_7_199 VDD VDD VSS VSS gf180mcu_fd_sc_mcu7t5v0__fill_1
XPHY_EDGE_ROW_4_Right_4 VDD VSS gf180mcu_fd_sc_mcu7t5v0__endcap
XFILLER_13_27 VDD VDD VSS VSS gf180mcu_fd_sc_mcu7t5v0__fill_2
XFILLER_5_72 VDD VDD VSS VSS gf180mcu_fd_sc_mcu7t5v0__fill_2
XTAP_TAPCELL_ROW_14_70 VDD VSS gf180mcu_fd_sc_mcu7t5v0__filltie
XFILLER_6_6 VDD VDD VSS VSS gf180mcu_fd_sc_mcu7t5v0__fill_1
X_070_ _070_/I _083_/A1 VDD VDD VSS VSS gf180mcu_fd_sc_mcu7t5v0__clkinv_1
Xmax_cap58 _180_/I _171_/I VDD VDD VSS VSS gf180mcu_fd_sc_mcu7t5v0__buf_4
XTAP_TAPCELL_ROW_11_60 VDD VSS gf180mcu_fd_sc_mcu7t5v0__filltie
X_122_ _122_/I _134_/RN VDD VDD VSS VSS gf180mcu_fd_sc_mcu7t5v0__clkinv_1
XTAP_TAPCELL_ROW_7_50 VDD VSS gf180mcu_fd_sc_mcu7t5v0__filltie
XPHY_EDGE_ROW_10_Left_25 VDD VSS gf180mcu_fd_sc_mcu7t5v0__endcap
X_105_ _109_/I _137_/RN VDD VDD VSS VSS gf180mcu_fd_sc_mcu7t5v0__clkinv_1
XFILLER_7_156 VDD VDD VSS VSS gf180mcu_fd_sc_mcu7t5v0__fill_1
XTAP_TAPCELL_ROW_14_71 VDD VSS gf180mcu_fd_sc_mcu7t5v0__filltie
XFILLER_14_93 VDD VDD VSS VSS gf180mcu_fd_sc_mcu7t5v0__fill_1
XFILLER_2_30 VDD VDD VSS VSS gf180mcu_fd_sc_mcu7t5v0__fillcap_4
Xmax_cap59 _141_/Q _089_/A1 VDD VDD VSS VSS gf180mcu_fd_sc_mcu7t5v0__buf_4
X_121_ _121_/I _133_/RN VDD VDD VSS VSS gf180mcu_fd_sc_mcu7t5v0__clkinv_1
XTAP_TAPCELL_ROW_11_61 VDD VSS gf180mcu_fd_sc_mcu7t5v0__filltie
XTAP_TAPCELL_ROW_7_51 VDD VSS gf180mcu_fd_sc_mcu7t5v0__filltie
X_104_ _121_/I _136_/RN VDD VDD VSS VSS gf180mcu_fd_sc_mcu7t5v0__clkinv_1
XFILLER_11_142 VDD VDD VSS VSS gf180mcu_fd_sc_mcu7t5v0__fill_2
XFILLER_13_29 VDD VDD VSS VSS gf180mcu_fd_sc_mcu7t5v0__fill_1
XPHY_EDGE_ROW_10_Right_10 VDD VSS gf180mcu_fd_sc_mcu7t5v0__endcap
X_120_ _122_/I _143_/Q _120_/Z VDD VDD VSS VSS gf180mcu_fd_sc_mcu7t5v0__or2_1
X_103_ _121_/I _135_/RN VDD VDD VSS VSS gf180mcu_fd_sc_mcu7t5v0__clkinv_1
XTAP_TAPCELL_ROW_4_42 VDD VSS gf180mcu_fd_sc_mcu7t5v0__filltie
XPHY_EDGE_ROW_8_Right_8 VDD VSS gf180mcu_fd_sc_mcu7t5v0__endcap
XFILLER_3_161 VDD VDD VSS VSS gf180mcu_fd_sc_mcu7t5v0__fill_1
XFILLER_0_197 VDD VDD VSS VSS gf180mcu_fd_sc_mcu7t5v0__fill_2
XFILLER_5_20 VDD VDD VSS VSS gf180mcu_fd_sc_mcu7t5v0__fillcap_4
XFILLER_4_6 VDD VDD VSS VSS gf180mcu_fd_sc_mcu7t5v0__fill_1
X_102_ _109_/I _123_/RN VDD VDD VSS VSS gf180mcu_fd_sc_mcu7t5v0__clkinv_1
XFILLER_7_137 VDD VDD VSS VSS gf180mcu_fd_sc_mcu7t5v0__fill_2
XFILLER_11_144 VDD VDD VSS VSS gf180mcu_fd_sc_mcu7t5v0__fill_1
XPHY_EDGE_ROW_14_Left_29 VDD VSS gf180mcu_fd_sc_mcu7t5v0__endcap
XTAP_TAPCELL_ROW_4_43 VDD VSS gf180mcu_fd_sc_mcu7t5v0__filltie
XPHY_EDGE_ROW_2_Left_17 VDD VSS gf180mcu_fd_sc_mcu7t5v0__endcap
Xclkbuf_0_CLK CLK clkbuf_0_CLK/Z VDD VDD VSS VSS gf180mcu_fd_sc_mcu7t5v0__clkbuf_16
XFILLER_2_22 VDD VDD VSS VSS gf180mcu_fd_sc_mcu7t5v0__fillcap_8
Xwire71 _155_/I _060_/I VDD VDD VSS VSS gf180mcu_fd_sc_mcu7t5v0__buf_4
Xwire82 wire82/I wire82/Z VDD VDD VSS VSS gf180mcu_fd_sc_mcu7t5v0__clkbuf_1
X_101_ _121_/I _124_/RN VDD VDD VSS VSS gf180mcu_fd_sc_mcu7t5v0__clkinv_1
XPHY_EDGE_ROW_5_Left_20 VDD VSS gf180mcu_fd_sc_mcu7t5v0__endcap
XFILLER_11_123 VDD VDD VSS VSS gf180mcu_fd_sc_mcu7t5v0__fill_2
XFILLER_8_21 VDD VDD VSS VSS gf180mcu_fd_sc_mcu7t5v0__fillcap_8
XTAP_TAPCELL_ROW_4_44 VDD VSS gf180mcu_fd_sc_mcu7t5v0__filltie
XFILLER_0_199 VDD VDD VSS VSS gf180mcu_fd_sc_mcu7t5v0__fill_1
XFILLER_2_34 VDD VDD VSS VSS gf180mcu_fd_sc_mcu7t5v0__fill_1
Xwire50 wire50/I _090_/S VDD VDD VSS VSS gf180mcu_fd_sc_mcu7t5v0__dlyb_1
Xwire72 _156_/I _061_/I VDD VDD VSS VSS gf180mcu_fd_sc_mcu7t5v0__buf_4
X_100_ _109_/I _125_/RN VDD VDD VSS VSS gf180mcu_fd_sc_mcu7t5v0__clkinv_1
XFILLER_7_139 VDD VDD VSS VSS gf180mcu_fd_sc_mcu7t5v0__fill_1
XFILLER_8_33 VDD VDD VSS VSS gf180mcu_fd_sc_mcu7t5v0__fill_2
XTAP_TAPCELL_ROW_1_35 VDD VSS gf180mcu_fd_sc_mcu7t5v0__filltie
Xwire51 wire51/I _086_/S VDD VDD VSS VSS gf180mcu_fd_sc_mcu7t5v0__dlyb_1
Xwire73 _157_/I _062_/I VDD VDD VSS VSS gf180mcu_fd_sc_mcu7t5v0__buf_4
X_159_ _159_/I _159_/Z VDD VDD VSS VSS gf180mcu_fd_sc_mcu7t5v0__buf_4
XFILLER_3_121 VDD VDD VSS VSS gf180mcu_fd_sc_mcu7t5v0__fill_2
XTAP_TAPCELL_ROW_1_36 VDD VSS gf180mcu_fd_sc_mcu7t5v0__filltie
X_175_ _175_/I _175_/Z VDD VDD VSS VSS gf180mcu_fd_sc_mcu7t5v0__buf_4
XFILLER_9_193 VDD VDD VSS VSS gf180mcu_fd_sc_mcu7t5v0__fill_1
Xwire52 wire52/I _082_/S VDD VDD VSS VSS gf180mcu_fd_sc_mcu7t5v0__dlyb_1
X_158_ _158_/I _158_/Z VDD VDD VSS VSS gf180mcu_fd_sc_mcu7t5v0__buf_4
X_089_ _089_/A1 _091_/A1 wire50/I VDD VDD VSS VSS gf180mcu_fd_sc_mcu7t5v0__nor2_1
XPHY_EDGE_ROW_9_Left_24 VDD VSS gf180mcu_fd_sc_mcu7t5v0__endcap
XPHY_EDGE_ROW_3_Right_3 VDD VSS gf180mcu_fd_sc_mcu7t5v0__endcap
XTAP_TAPCELL_ROW_14_67 VDD VSS gf180mcu_fd_sc_mcu7t5v0__filltie
XFILLER_11_46 VDD VDD VSS VSS gf180mcu_fd_sc_mcu7t5v0__fill_2
X_174_ _174_/I _174_/Z VDD VDD VSS VSS gf180mcu_fd_sc_mcu7t5v0__buf_1
XFILLER_14_135 VDD VDD VSS VSS gf180mcu_fd_sc_mcu7t5v0__fill_1
Xwire53 wire53/I _078_/S VDD VDD VSS VSS gf180mcu_fd_sc_mcu7t5v0__dlyb_1
X_157_ _157_/I _157_/Z VDD VDD VSS VSS gf180mcu_fd_sc_mcu7t5v0__buf_4
X_088_ _088_/I0 _088_/I1 _088_/S _125_/D VDD VDD VSS VSS gf180mcu_fd_sc_mcu7t5v0__mux2_2
XFILLER_3_123 VDD VDD VSS VSS gf180mcu_fd_sc_mcu7t5v0__fill_1
XFILLER_0_70 VDD VDD VSS VSS gf180mcu_fd_sc_mcu7t5v0__fillcap_8
XTAP_TAPCELL_ROW_14_68 VDD VSS gf180mcu_fd_sc_mcu7t5v0__filltie
XPHY_EDGE_ROW_13_Right_13 VDD VSS gf180mcu_fd_sc_mcu7t5v0__endcap
X_173_ _173_/I _173_/Z VDD VDD VSS VSS gf180mcu_fd_sc_mcu7t5v0__buf_1
XFILLER_11_14 VDD VDD VSS VSS gf180mcu_fd_sc_mcu7t5v0__fillcap_32
XFILLER_9_162 VDD VDD VSS VSS gf180mcu_fd_sc_mcu7t5v0__fill_1
Xwire54 wire54/I _074_/S VDD VDD VSS VSS gf180mcu_fd_sc_mcu7t5v0__dlyc_1
XFILLER_11_139 VDD VDD VSS VSS gf180mcu_fd_sc_mcu7t5v0__fill_1
X_156_ _156_/I _156_/Z VDD VDD VSS VSS gf180mcu_fd_sc_mcu7t5v0__buf_4
X_087_ _087_/A1 _141_/Q _088_/S VDD VDD VSS VSS gf180mcu_fd_sc_mcu7t5v0__nand2_1
XFILLER_8_37 VDD VDD VSS VSS gf180mcu_fd_sc_mcu7t5v0__fillcap_8
XFILLER_3_146 VDD VDD VSS VSS gf180mcu_fd_sc_mcu7t5v0__fill_1
X_139_ _169_/I _139_/RN _143_/CLK _168_/I VDD VDD VSS VSS gf180mcu_fd_sc_mcu7t5v0__dffrnq_2
XFILLER_10_8 VDD VDD VSS VSS gf180mcu_fd_sc_mcu7t5v0__fillcap_16
XTAP_TAPCELL_ROW_14_69 VDD VSS gf180mcu_fd_sc_mcu7t5v0__filltie
Xwire55 wire55/I _142_/D VDD VDD VSS VSS gf180mcu_fd_sc_mcu7t5v0__clkbuf_1
Xwire77 _161_/I wire77/Z VDD VDD VSS VSS gf180mcu_fd_sc_mcu7t5v0__buf_4
X_155_ _155_/I _155_/Z VDD VDD VSS VSS gf180mcu_fd_sc_mcu7t5v0__buf_4
X_086_ _086_/I0 _086_/I1 _086_/S _126_/D VDD VDD VSS VSS gf180mcu_fd_sc_mcu7t5v0__mux2_2
XFILLER_6_177 VDD VDD VSS VSS gf180mcu_fd_sc_mcu7t5v0__fill_2
X_138_ _168_/I _138_/RN _143_/CLK _167_/I VDD VDD VSS VSS gf180mcu_fd_sc_mcu7t5v0__dffrnq_2
X_069_ _069_/I _079_/A1 VDD VDD VSS VSS gf180mcu_fd_sc_mcu7t5v0__clkinv_1
XFILLER_0_50 VDD VDD VSS VSS gf180mcu_fd_sc_mcu7t5v0__fill_1
XPHY_EDGE_ROW_7_Right_7 VDD VSS gf180mcu_fd_sc_mcu7t5v0__endcap
XFILLER_14_26 VDD VDD VSS VSS gf180mcu_fd_sc_mcu7t5v0__fill_2
X_171_ _171_/I _171_/Z VDD VDD VSS VSS gf180mcu_fd_sc_mcu7t5v0__buf_4
XFILLER_3_72 VDD VDD VSS VSS gf180mcu_fd_sc_mcu7t5v0__fill_1
XFILLER_3_61 VDD VDD VSS VSS gf180mcu_fd_sc_mcu7t5v0__fillcap_8
X_154_ _154_/I _154_/Z VDD VDD VSS VSS gf180mcu_fd_sc_mcu7t5v0__buf_4
X_085_ _085_/A1 _087_/A1 wire51/I VDD VDD VSS VSS gf180mcu_fd_sc_mcu7t5v0__nor2_1
X_137_ _167_/I _137_/RN _143_/CLK _166_/I VDD VDD VSS VSS gf180mcu_fd_sc_mcu7t5v0__dffrnq_2
X_068_ _133_/D _075_/A1 VDD VDD VSS VSS gf180mcu_fd_sc_mcu7t5v0__clkinv_1
XPHY_EDGE_ROW_13_Left_28 VDD VSS gf180mcu_fd_sc_mcu7t5v0__endcap
XFILLER_14_16 VDD VDD VSS VSS gf180mcu_fd_sc_mcu7t5v0__fillcap_4
X_170_ _170_/I _170_/Z VDD VDD VSS VSS gf180mcu_fd_sc_mcu7t5v0__buf_4
XPHY_EDGE_ROW_1_Left_16 VDD VSS gf180mcu_fd_sc_mcu7t5v0__endcap
Xwire68 _173_/I _164_/I VDD VDD VSS VSS gf180mcu_fd_sc_mcu7t5v0__buf_4
X_084_ wire82/Z _158_/I _084_/S _127_/D VDD VDD VSS VSS gf180mcu_fd_sc_mcu7t5v0__mux2_2
XFILLER_8_29 VDD VDD VSS VSS gf180mcu_fd_sc_mcu7t5v0__fillcap_4
XFILLER_6_179 VDD VDD VSS VSS gf180mcu_fd_sc_mcu7t5v0__fill_1
XFILLER_6_102 VDD VDD VSS VSS gf180mcu_fd_sc_mcu7t5v0__fill_2
X_136_ _175_/I _136_/RN _142_/CLK _174_/I VDD VDD VSS VSS gf180mcu_fd_sc_mcu7t5v0__dffrnq_2
XFILLER_3_105 VDD VDD VSS VSS gf180mcu_fd_sc_mcu7t5v0__fill_1
XFILLER_0_30 VDD VDD VSS VSS gf180mcu_fd_sc_mcu7t5v0__fillcap_4
XFILLER_0_63 VDD VDD VSS VSS gf180mcu_fd_sc_mcu7t5v0__fillcap_4
X_067_ _162_/I _067_/ZN VDD VDD VSS VSS gf180mcu_fd_sc_mcu7t5v0__clkinv_1
X_119_ _121_/I _119_/A2 _119_/Z VDD VDD VSS VSS gf180mcu_fd_sc_mcu7t5v0__or2_1
Xwire69 _163_/I _133_/D VDD VDD VSS VSS gf180mcu_fd_sc_mcu7t5v0__buf_4
X_083_ _083_/A1 _085_/A1 _084_/S VDD VDD VSS VSS gf180mcu_fd_sc_mcu7t5v0__nand2_1
X_135_ _174_/I _135_/RN _142_/CLK _173_/I VDD VDD VSS VSS gf180mcu_fd_sc_mcu7t5v0__dffrnq_2
X_066_ _161_/I _066_/ZN VDD VDD VSS VSS gf180mcu_fd_sc_mcu7t5v0__clkinv_1
XFILLER_9_51 VDD VDD VSS VSS gf180mcu_fd_sc_mcu7t5v0__fill_1
XFILLER_2_183 VDD VDD VSS VSS gf180mcu_fd_sc_mcu7t5v0__fill_2
X_118_ _122_/I _143_/Q _118_/Z VDD VDD VSS VSS gf180mcu_fd_sc_mcu7t5v0__or2_1
Xoutput3 _058_/ZN B[0] VDD VDD VSS VSS gf180mcu_fd_sc_mcu7t5v0__buf_1
XFILLER_9_189 VDD VDD VSS VSS gf180mcu_fd_sc_mcu7t5v0__fillcap_4
X_082_ _157_/I _082_/I1 _082_/S _128_/D VDD VDD VSS VSS gf180mcu_fd_sc_mcu7t5v0__mux2_2
XTAP_TAPCELL_ROW_12_62 VDD VSS gf180mcu_fd_sc_mcu7t5v0__filltie
XFILLER_6_104 VDD VDD VSS VSS gf180mcu_fd_sc_mcu7t5v0__fill_1
XFILLER_10_199 VDD VDD VSS VSS gf180mcu_fd_sc_mcu7t5v0__fill_1
XTAP_TAPCELL_ROW_8_52 VDD VSS gf180mcu_fd_sc_mcu7t5v0__filltie
X_134_ _164_/I _134_/RN _143_/CLK _163_/I VDD VDD VSS VSS gf180mcu_fd_sc_mcu7t5v0__dffrnq_2
X_065_ _160_/I _065_/ZN VDD VDD VSS VSS gf180mcu_fd_sc_mcu7t5v0__clkinv_1
X_117_ _122_/I _143_/Q _117_/Z VDD VDD VSS VSS gf180mcu_fd_sc_mcu7t5v0__or2_1
XFILLER_9_8 VDD VDD VSS VSS gf180mcu_fd_sc_mcu7t5v0__fill_1
Xoutput4 _059_/ZN B[1] VDD VDD VSS VSS gf180mcu_fd_sc_mcu7t5v0__buf_1
XFILLER_13_142 VDD VDD VSS VSS gf180mcu_fd_sc_mcu7t5v0__fill_2
XFILLER_3_21 VDD VDD VSS VSS gf180mcu_fd_sc_mcu7t5v0__fillcap_4
X_081_ _175_/I _083_/A1 wire52/I VDD VDD VSS VSS gf180mcu_fd_sc_mcu7t5v0__nor2_1
XTAP_TAPCELL_ROW_12_63 VDD VSS gf180mcu_fd_sc_mcu7t5v0__filltie
XFILLER_12_30 VDD VDD VSS VSS gf180mcu_fd_sc_mcu7t5v0__fillcap_4
XTAP_TAPCELL_ROW_8_53 VDD VSS gf180mcu_fd_sc_mcu7t5v0__filltie
XFILLER_0_22 VDD VDD VSS VSS gf180mcu_fd_sc_mcu7t5v0__fillcap_8
XFILLER_0_44 VDD VDD VSS VSS gf180mcu_fd_sc_mcu7t5v0__fillcap_4
X_133_ _133_/D _133_/RN _142_/CLK _133_/Q VDD VDD VSS VSS gf180mcu_fd_sc_mcu7t5v0__dffrnq_1
X_064_ _159_/I _064_/ZN VDD VDD VSS VSS gf180mcu_fd_sc_mcu7t5v0__clkinv_1
XFILLER_2_185 VDD VDD VSS VSS gf180mcu_fd_sc_mcu7t5v0__fill_1
XFILLER_0_55 VDD VDD VSS VSS gf180mcu_fd_sc_mcu7t5v0__fillcap_8
XPHY_EDGE_ROW_8_Left_23 VDD VSS gf180mcu_fd_sc_mcu7t5v0__endcap
X_116_ _121_/I _119_/A2 _116_/Z VDD VDD VSS VSS gf180mcu_fd_sc_mcu7t5v0__or2_1
XPHY_EDGE_ROW_2_Right_2 VDD VSS gf180mcu_fd_sc_mcu7t5v0__endcap
XFILLER_6_21 VDD VDD VSS VSS gf180mcu_fd_sc_mcu7t5v0__fillcap_4
Xoutput40 _133_/D SW1p[0] VDD VDD VSS VSS gf180mcu_fd_sc_mcu7t5v0__buf_1
Xoutput5 _060_/ZN B[2] VDD VDD VSS VSS gf180mcu_fd_sc_mcu7t5v0__buf_1
Xclkbuf_1_0__f_CLK clkbuf_0_CLK/Z _143_/CLK VDD VDD VSS VSS gf180mcu_fd_sc_mcu7t5v0__clkbuf_16
XFILLER_3_88 VDD VDD VSS VSS gf180mcu_fd_sc_mcu7t5v0__fill_1
X_080_ _086_/I1 _061_/I _080_/S _129_/D VDD VDD VSS VSS gf180mcu_fd_sc_mcu7t5v0__mux2_2
XTAP_TAPCELL_ROW_12_64 VDD VSS gf180mcu_fd_sc_mcu7t5v0__filltie
XFILLER_12_20 VDD VDD VSS VSS gf180mcu_fd_sc_mcu7t5v0__fill_1
XTAP_TAPCELL_ROW_8_54 VDD VSS gf180mcu_fd_sc_mcu7t5v0__filltie
X_132_ _132_/D _132_/RN _120_/Z _143_/CLK _132_/Q VDD VDD VSS VSS gf180mcu_fd_sc_mcu7t5v0__dffrsnq_1
X_063_ _063_/I _063_/ZN VDD VDD VSS VSS gf180mcu_fd_sc_mcu7t5v0__clkinv_1
XFILLER_0_67 VDD VDD VSS VSS gf180mcu_fd_sc_mcu7t5v0__fill_1
XFILLER_0_78 VDD VDD VSS VSS gf180mcu_fd_sc_mcu7t5v0__fillcap_4
XFILLER_9_87 VDD VDD VSS VSS gf180mcu_fd_sc_mcu7t5v0__fill_2
X_115_ _121_/I _119_/A2 _115_/Z VDD VDD VSS VSS gf180mcu_fd_sc_mcu7t5v0__or2_1
XFILLER_13_2 VDD VDD VSS VSS gf180mcu_fd_sc_mcu7t5v0__fillcap_4
Xoutput30 _162_/Z SW0p[8] VDD VDD VSS VSS gf180mcu_fd_sc_mcu7t5v0__buf_4
Xoutput41 _173_/Z SW1p[1] VDD VDD VSS VSS gf180mcu_fd_sc_mcu7t5v0__buf_1
Xoutput6 _061_/ZN B[3] VDD VDD VSS VSS gf180mcu_fd_sc_mcu7t5v0__buf_1
.ends
