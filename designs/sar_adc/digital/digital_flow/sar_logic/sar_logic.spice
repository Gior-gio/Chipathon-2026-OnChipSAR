* ==========================================
* LVS READY - MÓDULO: SAR_LOGIC
* ==========================================

.SUBCKT gf180mcu_fd_sc_mcu7t5v0__antenna I VDD VNW VPW VSS
D0 VPW I diode_nd2ps_06v0 AREA=0.2052p PJ=1.86u M=1
D1 I VNW diode_pd2nw_06v0 AREA=0.2052p PJ=1.86u M=1
.ENDS
.SUBCKT gf180mcu_fd_sc_mcu7t5v0__buf_1 I Z VDD VNW VPW VSS
X_i_2 VSS I Z_neg VPW nfet_05v0 W=3.6e-07 L=6e-07
X_i_0 Z Z_neg VSS VPW nfet_05v0 W=8.2e-07 L=6e-07
X_i_3 VDD I Z_neg VNW pfet_05v0 W=5.65e-07 L=5e-07
X_i_1 Z Z_neg VDD VNW pfet_05v0 W=1.22e-06 L=5e-07
.ENDS
.SUBCKT gf180mcu_fd_sc_mcu7t5v0__clkbuf_16 I Z VDD VNW VPW VSS
X_i_2_0 Z_neg I VSS VPW nfet_05v0 W=4.05e-07 L=6e-07
X_i_2_1 VSS I Z_neg VPW nfet_05v0 W=4.05e-07 L=6e-07
X_i_2_2 Z_neg I VSS VPW nfet_05v0 W=4.05e-07 L=6e-07
X_i_2_3 VSS I Z_neg VPW nfet_05v0 W=4.05e-07 L=6e-07
X_i_2_4 Z_neg I VSS VPW nfet_05v0 W=4.05e-07 L=6e-07
X_i_2_5 VSS I Z_neg VPW nfet_05v0 W=4.05e-07 L=6e-07
X_i_0_0 Z Z_neg VSS VPW nfet_05v0 W=4.85e-07 L=6e-07
X_i_0_1 VSS Z_neg Z VPW nfet_05v0 W=4.85e-07 L=6e-07
X_i_0_2 Z Z_neg VSS VPW nfet_05v0 W=4.85e-07 L=6e-07
X_i_0_3 VSS Z_neg Z VPW nfet_05v0 W=4.85e-07 L=6e-07
X_i_0_4 Z Z_neg VSS VPW nfet_05v0 W=4.85e-07 L=6e-07
X_i_0_5 VSS Z_neg Z VPW nfet_05v0 W=4.85e-07 L=6e-07
X_i_0_6 Z Z_neg VSS VPW nfet_05v0 W=4.85e-07 L=6e-07
X_i_0_7 VSS Z_neg Z VPW nfet_05v0 W=4.85e-07 L=6e-07
X_i_0_8 Z Z_neg VSS VPW nfet_05v0 W=4.85e-07 L=6e-07
X_i_0_9 VSS Z_neg Z VPW nfet_05v0 W=4.85e-07 L=6e-07
X_i_0_10 Z Z_neg VSS VPW nfet_05v0 W=4.85e-07 L=6e-07
X_i_0_11 VSS Z_neg Z VPW nfet_05v0 W=4.85e-07 L=6e-07
X_i_0_12 Z Z_neg VSS VPW nfet_05v0 W=4.85e-07 L=6e-07
X_i_0_13 VSS Z_neg Z VPW nfet_05v0 W=4.85e-07 L=6e-07
X_i_0_14 Z Z_neg VSS VPW nfet_05v0 W=4.85e-07 L=6e-07
X_i_0_15 VSS Z_neg Z VPW nfet_05v0 W=4.85e-07 L=6e-07
X_i_3_0 Z_neg I VDD VNW pfet_05v0 W=0.82e-06 L=5e-07
X_i_3_1 VDD I Z_neg VNW pfet_05v0 W=0.82e-06 L=5e-07
X_i_3_2 Z_neg I VDD VNW pfet_05v0 W=0.82e-06 L=5e-07
X_i_3_3 VDD I Z_neg VNW pfet_05v0 W=0.82e-06 L=5e-07
X_i_3_4 Z_neg I VDD VNW pfet_05v0 W=0.82e-06 L=5e-07
X_i_3_5 VDD I Z_neg VNW pfet_05v0 W=0.82e-06 L=5e-07
X_i_3_6 Z_neg I VDD VNW pfet_05v0 W=0.82e-06 L=5e-07
X_i_3_7 VDD I Z_neg VNW pfet_05v0 W=0.82e-06 L=5e-07
X_i_1_0 Z Z_neg VDD VNW pfet_05v0 W=1.22e-06 L=5e-07
X_i_1_1 VDD Z_neg Z VNW pfet_05v0 W=1.22e-06 L=5e-07
X_i_1_2 Z Z_neg VDD VNW pfet_05v0 W=1.22e-06 L=5e-07
X_i_1_3 VDD Z_neg Z VNW pfet_05v0 W=1.22e-06 L=5e-07
X_i_1_4 Z Z_neg VDD VNW pfet_05v0 W=1.22e-06 L=5e-07
X_i_1_5 VDD Z_neg Z VNW pfet_05v0 W=1.22e-06 L=5e-07
X_i_1_6 Z Z_neg VDD VNW pfet_05v0 W=1.22e-06 L=5e-07
X_i_1_7 VDD Z_neg Z VNW pfet_05v0 W=1.22e-06 L=5e-07
X_i_1_8 Z Z_neg VDD VNW pfet_05v0 W=1.22e-06 L=5e-07
X_i_1_9 VDD Z_neg Z VNW pfet_05v0 W=1.22e-06 L=5e-07
X_i_1_10 Z Z_neg VDD VNW pfet_05v0 W=1.22e-06 L=5e-07
X_i_1_11 VDD Z_neg Z VNW pfet_05v0 W=1.22e-06 L=5e-07
X_i_1_12 Z Z_neg VDD VNW pfet_05v0 W=1.22e-06 L=5e-07
X_i_1_13 VDD Z_neg Z VNW pfet_05v0 W=1.22e-06 L=5e-07
X_i_1_14 Z Z_neg VDD VNW pfet_05v0 W=1.22e-06 L=5e-07
X_i_1_15 VDD Z_neg Z VNW pfet_05v0 W=1.22e-06 L=5e-07
.ENDS
.SUBCKT gf180mcu_fd_sc_mcu7t5v0__clkinv_1 I ZN VDD VNW VPW VSS
X_i_0 ZN I VSS VPW nfet_05v0 W=4.8e-07 L=6e-07
X_i_1 ZN I VDD VNW pfet_05v0 W=1.22e-06 L=5e-07
.ENDS
.SUBCKT gf180mcu_fd_sc_mcu7t5v0__dffrnq_1 D RN CLK Q VDD VNW VPW VSS
X_tn10 ncki CLK VSS VPW nfet_05v0 W=4.05e-07 L=6e-07
X_tn13 cki ncki VSS VPW nfet_05v0 W=4.05e-07 L=6e-07
X_tn11 net10 D VSS VPW nfet_05v0 W=3.6e-07 L=6e-07
X_tn15 net10 ncki net1 VPW nfet_05v0 W=3.6e-07 L=6e-07
X_tn14 net1 cki net15 VPW nfet_05v0 W=3.6e-07 L=6e-07
X_tn8 net12 net2 net15 VPW nfet_05v0 W=3.6e-07 L=6e-07
X_tn9 VSS RN net12 VPW nfet_05v0 W=3.6e-07 L=6e-07
X_tn18 VSS net1 net2 VPW nfet_05v0 W=3.6e-07 L=6e-07
X_tn0 net8 cki net2 VPW nfet_05v0 W=3.6e-07 L=6e-07
X_tn1 net11 ncki net8 VPW nfet_05v0 W=3.6e-07 L=6e-07
X_tn12 net11 net4 VSS VPW nfet_05v0 W=3.6e-07 L=6e-07
X_tn5 net0 RN VSS VPW nfet_05v0 W=3.6e-07 L=6e-07
X_tn4 net4 net8 net0 VPW nfet_05v0 W=4e-07 L=6e-07
X_tn3 Q net4 VSS VPW nfet_05v0 W=8.15e-07 L=6e-07
X_tp8 ncki CLK VDD VNW pfet_05v0 W=8.65e-07 L=5e-07
X_tp11 cki ncki VDD VNW pfet_05v0 W=8.65e-07 L=5e-07
X_tp9 VDD D net10 VNW pfet_05v0 W=7.8e-07 L=5e-07
X_tp15 net1 cki net10 VNW pfet_05v0 W=7.8e-07 L=5e-07
X_tp7 net9 ncki net1 VNW pfet_05v0 W=7.8e-07 L=5e-07
X_tp6 VDD net2 net9 VNW pfet_05v0 W=7.8e-07 L=5e-07
X_tp12 net9 RN VDD VNW pfet_05v0 W=7.8e-07 L=5e-07
X_tp18 VDD net1 net2 VNW pfet_05v0 W=5.05e-07 L=5e-07
X_tp2 net2 ncki net8 VNW pfet_05v0 W=5.05e-07 L=5e-07
X_tp3 net8 cki net11 VNW pfet_05v0 W=5.05e-07 L=5e-07
X_tp10 net11 net4 VDD VNW pfet_05v0 W=5.05e-07 L=5e-07
X_tp5 net4 RN VDD VNW pfet_05v0 W=1e-06 L=5e-07
X_tp4 VDD net8 net4 VNW pfet_05v0 W=1e-06 L=5e-07
X_tp1 Q net4 VDD VNW pfet_05v0 W=1.215e-06 L=5e-07
.ENDS
.SUBCKT gf180mcu_fd_sc_mcu7t5v0__dlyb_1 I Z VDD VNW VPW VSS
X_i_2_0 Z_neg I VSS VPW nfet_05v0 W=3.6e-07 L=6e-07
X_i_2 net_2 Z_neg net_1 VPW nfet_05v0 W=3.6e-07 L=6e-07
X_i_3 net_1 Z_neg VSS VPW nfet_05v0 W=3.6e-07 L=6e-07
X_i_2_21 net_3 net_2 net_6 VPW nfet_05v0 W=3.65e-07 L=0.600000U
X_i_3_6 net_6 net_2 VSS VPW nfet_05v0 W=3.65e-07 L=6e-07
X_i_2_0_18 Z net_3 VSS VPW nfet_05v0 W=8.2e-07 L=6e-07
X_i_3_0 Z_neg I VDD VNW pfet_05v0 W=3.6e-07 L=5e-07
X_i_0 net_0 Z_neg VDD VNW pfet_05v0 W=3.6e-07 L=5e-07
X_i_1 net_2 Z_neg net_0 VNW pfet_05v0 W=3.6e-07 L=5e-07
X_i_0_29 net_5 net_2 VDD VNW pfet_05v0 W=3.6e-07 L=5e-07
X_i_1_39 net_3 net_2 net_5 VNW pfet_05v0 W=3.6e-07 L=5e-07
X_i_3_0_0 Z net_3 VDD VNW pfet_05v0 W=1.22e-06 L=5e-07
.ENDS
.SUBCKT gf180mcu_fd_sc_mcu7t5v0__endcap VDD VSS
.ENDS
.SUBCKT gf180mcu_fd_sc_mcu7t5v0__fill_1 VDD VNW VPW VSS
.ENDS
.SUBCKT gf180mcu_fd_sc_mcu7t5v0__fill_2 VDD VNW VPW VSS
.ENDS
.SUBCKT gf180mcu_fd_sc_mcu7t5v0__fillcap_4 VDD VNW VPW VSS
X_i_17 net_1 net_0 VSS VPW nfet_05v0 W=8.2e-07 L=1e-06
X_i_19 VDD net_1 net_0 VNW pfet_05v0 W=1.22e-06 L=1e-06
.ENDS
.SUBCKT gf180mcu_fd_sc_mcu7t5v0__fillcap_8 VDD VNW VPW VSS
X_i_17 net_3 net_2 VSS VPW nfet_05v0 W=8.2e-07 L=1e-06
X_i_17_23 net_4 net_5 VSS VPW nfet_05v0 W=8.2e-07 L=1e-06
X_i_19 VDD net_3 net_2 VNW pfet_05v0 W=1.22e-06 L=1e-06
X_i_19_7 VDD net_4 net_5 VNW pfet_05v0 W=1.22e-06 L=1e-06
.ENDS
.SUBCKT gf180mcu_fd_sc_mcu7t5v0__fillcap_16 VDD VNW VPW VSS
X_i_17 net_3 net_2 VSS VPW nfet_05v0 W=8.2e-07 L=1e-06
X_i_17_23 net_4 net_5 VSS VPW nfet_05v0 W=8.2e-07 L=1e-06
X_i_17_24 net_7 net_9 VSS VPW nfet_05v0 W=8.2e-07 L=1e-06
X_i_17_23_55 net_6 net_8 VSS VPW nfet_05v0 W=8.2e-07 L=1e-06
X_i_19 VDD net_3 net_2 VNW pfet_05v0 W=1.22e-06 L=1e-06
X_i_19_7 VDD net_4 net_5 VNW pfet_05v0 W=1.22e-06 L=1e-06
X_i_19_33 VDD net_7 net_9 VNW pfet_05v0 W=1.22e-06 L=1e-06
X_i_19_7_23 VDD net_6 net_8 VNW pfet_05v0 W=1.22e-06 L=1e-06
.ENDS
.SUBCKT gf180mcu_fd_sc_mcu7t5v0__fillcap_32 VDD VNW VPW VSS
X_i_17 net_3 net_2 VSS VPW nfet_05v0 W=8.2e-07 L=1e-06
X_i_17_23 net_4 net_5 VSS VPW nfet_05v0 W=8.2e-07 L=1e-06
X_i_17_24 net_7 net_9 VSS VPW nfet_05v0 W=8.2e-07 L=1e-06
X_i_17_23_55 net_6 net_8 VSS VPW nfet_05v0 W=8.2e-07 L=1e-06
X_i_17_27 net_17 net_14 VSS VPW nfet_05v0 W=8.2e-07 L=1e-06
X_i_17_23_63 net_16 net_15 VSS VPW nfet_05v0 W=8.2e-07 L=1e-06
X_i_17_24_22 net_13 net_11 VSS VPW nfet_05v0 W=8.2e-07 L=1e-06
X_i_17_23_55_93 net_12 net_10 VSS VPW nfet_05v0 W=8.2e-07 L=1e-06
X_i_19 VDD net_3 net_2 VNW pfet_05v0 W=1.22e-06 L=1e-06
X_i_19_7 VDD net_4 net_5 VNW pfet_05v0 W=1.22e-06 L=1e-06
X_i_19_33 VDD net_7 net_9 VNW pfet_05v0 W=1.22e-06 L=1e-06
X_i_19_7_23 VDD net_6 net_8 VNW pfet_05v0 W=1.22e-06 L=1e-06
X_i_19_94 VDD net_17 net_14 VNW pfet_05v0 W=1.22e-06 L=1e-06
X_i_19_7_87 VDD net_16 net_15 VNW pfet_05v0 W=1.22e-06 L=1e-06
X_i_19_33_95 VDD net_13 net_11 VNW pfet_05v0 W=1.22e-06 L=1e-06
X_i_19_7_23_23 VDD net_12 net_10 VNW pfet_05v0 W=1.22e-06 L=1e-06
.ENDS
.SUBCKT gf180mcu_fd_sc_mcu7t5v0__filltie VDD VSS
.ENDS
.SUBCKT gf180mcu_fd_sc_mcu7t5v0__tieh Z VDD VNW VPW VSS
X_n_tran_1 VSS A A VPW nfet_05v0 W=0.82U L=0.600000U
X_p_tran_2 VDD A Z VNW pfet_05v0 W=1.22e-06 L=5e-07
.ENDS

* --- DISEÑO DIGITAL ---
.subckt sar_logic B[0] B[1] B[2] B[3] B[4] B[5] B[6] B[7] B[8] B[9] CLK SAMP SW0[0]

X1 VDD VDD VSS VSS GF180MCU_FD_SC_MCU7T5V0__FILL_2
X2 VDD VDD VSS VSS GF180MCU_FD_SC_MCU7T5V0__FILLCAP_4
X3 VDD VDD VSS VSS GF180MCU_FD_SC_MCU7T5V0__FILL_2
X4 VDD VDD VSS VSS GF180MCU_FD_SC_MCU7T5V0__FILLCAP_8
X5 _83_/I _83_/Z VDD VDD VSS VSS GF180MCU_FD_SC_MCU7T5V0__BUF_1
X6 VDD VDD VSS VSS GF180MCU_FD_SC_MCU7T5V0__FILL_2
X7 _84_/I _66_/RN _68_/CLK _85_/I VDD VDD VSS VSS GF180MCU_FD_SC_MCU7T5V0__DFFRNQ_1
X8 _49_/I _59_/RN VDD VDD VSS VSS GF180MCU_FD_SC_MCU7T5V0__CLKINV_1
X9 VDD VDD VSS VSS GF180MCU_FD_SC_MCU7T5V0__FILL_1
X10 VDD VDD VSS VSS GF180MCU_FD_SC_MCU7T5V0__FILLCAP_4
X11 _25_/ZN B[4] VDD VDD VSS VSS GF180MCU_FD_SC_MCU7T5V0__DLYB_1
X12 _79_/Z SW0[7] VDD VDD VSS VSS GF180MCU_FD_SC_MCU7T5V0__DLYB_1
X13 VDD VDD VSS VSS GF180MCU_FD_SC_MCU7T5V0__FILL_1
X14 VDD VSS GF180MCU_FD_SC_MCU7T5V0__ENDCAP
X15 _82_/I _82_/Z VDD VDD VSS VSS GF180MCU_FD_SC_MCU7T5V0__BUF_1
X16 _83_/I _65_/RN _70_/CLK _84_/I VDD VDD VSS VSS GF180MCU_FD_SC_MCU7T5V0__DFFRNQ_1
X17 VDD VDD VSS VSS GF180MCU_FD_SC_MCU7T5V0__FILLCAP_8
X18 _48_/I _58_/RN VDD VDD VSS VSS GF180MCU_FD_SC_MCU7T5V0__CLKINV_1
X19 VDD VDD VSS VSS GF180MCU_FD_SC_MCU7T5V0__FILLCAP_8
X20 VDD VSS GF180MCU_FD_SC_MCU7T5V0__ENDCAP
X21 VDD VSS GF180MCU_FD_SC_MCU7T5V0__FILLTIE
X22 _26_/ZN B[5] VDD VDD VSS VSS GF180MCU_FD_SC_MCU7T5V0__DLYB_1
X23 _80_/Z SW0[8] VDD VDD VSS VSS GF180MCU_FD_SC_MCU7T5V0__DLYB_1
X24 _28_/ZN B[7] VDD VDD VSS VSS GF180MCU_FD_SC_MCU7T5V0__DLYB_1
X25 VDD VDD VSS VSS GF180MCU_FD_SC_MCU7T5V0__FILL_1
X26 VDD VDD VSS VSS GF180MCU_FD_SC_MCU7T5V0__FILL_2
X27 VDD VDD VSS VSS GF180MCU_FD_SC_MCU7T5V0__FILL_1
X28 VDD VDD VSS VSS GF180MCU_FD_SC_MCU7T5V0__FILL_1
X29 VDD VDD VSS VSS GF180MCU_FD_SC_MCU7T5V0__FILL_2
X30 VDD VDD VSS VSS GF180MCU_FD_SC_MCU7T5V0__FILL_1
X31 VDD VSS GF180MCU_FD_SC_MCU7T5V0__FILLTIE
X32 _81_/I _81_/Z VDD VDD VSS VSS GF180MCU_FD_SC_MCU7T5V0__BUF_1
X33 VDD VDD VSS VSS GF180MCU_FD_SC_MCU7T5V0__FILLCAP_4
X34 VDD VDD VSS VSS GF180MCU_FD_SC_MCU7T5V0__FILL_2
X35 VDD VDD VSS VSS GF180MCU_FD_SC_MCU7T5V0__FILLCAP_4
X36 _82_/I _64_/RN _70_/CLK _83_/I VDD VDD VSS VSS GF180MCU_FD_SC_MCU7T5V0__DFFRNQ_1
X37 _48_/I _57_/RN VDD VDD VSS VSS GF180MCU_FD_SC_MCU7T5V0__CLKINV_1
X38 VDD VSS GF180MCU_FD_SC_MCU7T5V0__ENDCAP
X39 VDD VSS GF180MCU_FD_SC_MCU7T5V0__FILLTIE
X40 _27_/ZN B[6] VDD VDD VSS VSS GF180MCU_FD_SC_MCU7T5V0__DLYB_1
X41 _81_/Z SW1[0] VDD VDD VSS VSS GF180MCU_FD_SC_MCU7T5V0__DLYB_1
X42 _29_/ZN B[8] VDD VDD VSS VSS GF180MCU_FD_SC_MCU7T5V0__DLYB_1
X43 VDD VSS GF180MCU_FD_SC_MCU7T5V0__ENDCAP
X44 VDD VSS GF180MCU_FD_SC_MCU7T5V0__FILLTIE
X45 _80_/I _80_/Z VDD VDD VSS VSS GF180MCU_FD_SC_MCU7T5V0__BUF_1
X46 _81_/I _63_/RN _68_/CLK _82_/I VDD VDD VSS VSS GF180MCU_FD_SC_MCU7T5V0__DFFRNQ_1
X47 VDD VDD VSS VSS GF180MCU_FD_SC_MCU7T5V0__FILL_1
X48 _48_/I _56_/RN VDD VDD VSS VSS GF180MCU_FD_SC_MCU7T5V0__CLKINV_1
X49 VDD VDD VSS VSS GF180MCU_FD_SC_MCU7T5V0__FILLCAP_8
X50 _82_/Z SW1[1] VDD VDD VSS VSS GF180MCU_FD_SC_MCU7T5V0__DLYB_1
X51 _30_/ZN B[9] VDD VDD VSS VSS GF180MCU_FD_SC_MCU7T5V0__DLYB_1
X52 _79_/I _29_/ZN VDD VDD VSS VSS GF180MCU_FD_SC_MCU7T5V0__CLKINV_1
X53 VDD VDD VSS VSS GF180MCU_FD_SC_MCU7T5V0__FILL_2
X54 VDD VDD VSS VSS GF180MCU_FD_SC_MCU7T5V0__FILL_2
X55 VDD VDD VSS VSS GF180MCU_FD_SC_MCU7T5V0__FILL_1
X56 VDD VDD VSS VSS GF180MCU_FD_SC_MCU7T5V0__FILL_1
X57 VDD VDD VSS VSS GF180MCU_FD_SC_MCU7T5V0__FILL_1
X58 VDD VDD VSS VSS GF180MCU_FD_SC_MCU7T5V0__FILL_1
X59 VDD VDD VSS VSS GF180MCU_FD_SC_MCU7T5V0__FILLCAP_4
X60 VDD VSS GF180MCU_FD_SC_MCU7T5V0__FILLTIE
X61 _62_/D _62_/RN _68_/CLK _81_/I VDD VDD VSS VSS GF180MCU_FD_SC_MCU7T5V0__DFFRNQ_1
X62 VDD VDD VSS VSS GF180MCU_FD_SC_MCU7T5V0__FILLCAP_16
X63 _78_/I _28_/ZN VDD VDD VSS VSS GF180MCU_FD_SC_MCU7T5V0__CLKINV_1
X64 _50_/I _55_/RN VDD VDD VSS VSS GF180MCU_FD_SC_MCU7T5V0__CLKINV_1
X65 _83_/Z SW1[2] VDD VDD VSS VSS GF180MCU_FD_SC_MCU7T5V0__DLYB_1
X66 _72_/Z SW0[0] VDD VDD VSS VSS GF180MCU_FD_SC_MCU7T5V0__DLYB_1
X67 SAMP VDD VDD VSS VSS GF180MCU_FD_SC_MCU7T5V0__ANTENNA
X68 VDD VDD VSS VSS GF180MCU_FD_SC_MCU7T5V0__FILLCAP_16
X69 VDD VSS GF180MCU_FD_SC_MCU7T5V0__FILLTIE
X70 _61_/D _61_/RN _70_/CLK _62_/D VDD VDD VSS VSS GF180MCU_FD_SC_MCU7T5V0__DFFRNQ_1
X71 VDD VDD VSS VSS GF180MCU_FD_SC_MCU7T5V0__FILLCAP_8
X72 VDD VDD VSS VSS GF180MCU_FD_SC_MCU7T5V0__FILL_1
X73 clkbuf_0_CLK/Z _70_/CLK VDD VDD VSS VSS GF180MCU_FD_SC_MCU7T5V0__CLKBUF_16
X74 _48_/I _54_/RN VDD VDD VSS VSS GF180MCU_FD_SC_MCU7T5V0__CLKINV_1
X75 _77_/I _27_/ZN VDD VDD VSS VSS GF180MCU_FD_SC_MCU7T5V0__CLKINV_1
X76 VDD VDD VSS VSS GF180MCU_FD_SC_MCU7T5V0__FILLCAP_16
X77 VDD VDD VSS VSS GF180MCU_FD_SC_MCU7T5V0__FILL_1
X78 _84_/Z SW1[3] VDD VDD VSS VSS GF180MCU_FD_SC_MCU7T5V0__DLYB_1
X79 _73_/Z SW0[1] VDD VDD VSS VSS GF180MCU_FD_SC_MCU7T5V0__DLYB_1
X80 VDD VSS GF180MCU_FD_SC_MCU7T5V0__ENDCAP
X81 _60_/D _60_/RN _62_/D _60_/Q VDD VDD VSS VSS GF180MCU_FD_SC_MCU7T5V0__DFFRNQ_1
X82 _76_/I _26_/ZN VDD VDD VSS VSS GF180MCU_FD_SC_MCU7T5V0__CLKINV_1
X83 _50_/I _53_/RN VDD VDD VSS VSS GF180MCU_FD_SC_MCU7T5V0__CLKINV_1
X84 VDD VDD VSS VSS GF180MCU_FD_SC_MCU7T5V0__FILLCAP_4
X85 VDD VSS GF180MCU_FD_SC_MCU7T5V0__ENDCAP
X86 VDD VSS GF180MCU_FD_SC_MCU7T5V0__ENDCAP
X87 _85_/Z SW1[4] VDD VDD VSS VSS GF180MCU_FD_SC_MCU7T5V0__DLYB_1
X88 _74_/Z SW0[2] VDD VDD VSS VSS GF180MCU_FD_SC_MCU7T5V0__DLYB_1
X89 VDD VDD VSS VSS GF180MCU_FD_SC_MCU7T5V0__FILLCAP_4
X90 VDD VDD VSS VSS GF180MCU_FD_SC_MCU7T5V0__FILLCAP_16
X91 VDD VDD VSS VSS GF180MCU_FD_SC_MCU7T5V0__FILLCAP_8
X92 VDD VSS GF180MCU_FD_SC_MCU7T5V0__FILLTIE
X93 VDD VSS GF180MCU_FD_SC_MCU7T5V0__FILLTIE
X94 _48_/I _52_/RN VDD VDD VSS VSS GF180MCU_FD_SC_MCU7T5V0__CLKINV_1
X95 VDD VDD VSS VSS GF180MCU_FD_SC_MCU7T5V0__FILL_2
X96 _75_/I _25_/ZN VDD VDD VSS VSS GF180MCU_FD_SC_MCU7T5V0__CLKINV_1
X97 _86_/Z SW1[5] VDD VDD VSS VSS GF180MCU_FD_SC_MCU7T5V0__DLYB_1
X98 _75_/Z SW0[3] VDD VDD VSS VSS GF180MCU_FD_SC_MCU7T5V0__DLYB_1
X99 VDD VDD VSS VSS GF180MCU_FD_SC_MCU7T5V0__FILL_1
X100 VDD VDD VSS VSS GF180MCU_FD_SC_MCU7T5V0__FILLCAP_16
X101 VDD VSS GF180MCU_FD_SC_MCU7T5V0__FILLTIE
X102 VDD VSS GF180MCU_FD_SC_MCU7T5V0__FILLTIE
X103 _74_/I _24_/ZN VDD VDD VSS VSS GF180MCU_FD_SC_MCU7T5V0__CLKINV_1
X104 _48_/I _51_/RN VDD VDD VSS VSS GF180MCU_FD_SC_MCU7T5V0__CLKINV_1
X105 VDD VDD VSS VSS GF180MCU_FD_SC_MCU7T5V0__FILLCAP_4
X106 _87_/Z SW1[6] VDD VDD VSS VSS GF180MCU_FD_SC_MCU7T5V0__DLYB_1
X107 _76_/Z SW0[4] VDD VDD VSS VSS GF180MCU_FD_SC_MCU7T5V0__DLYB_1
X108 VDD VDD VSS VSS GF180MCU_FD_SC_MCU7T5V0__FILLCAP_4
X109 VDD VSS GF180MCU_FD_SC_MCU7T5V0__FILLTIE
X110 _48_/I _70_/RN VDD VDD VSS VSS GF180MCU_FD_SC_MCU7T5V0__CLKINV_1
X111 VDD VDD VSS VSS GF180MCU_FD_SC_MCU7T5V0__FILL_1
X112 VDD VDD VSS VSS GF180MCU_FD_SC_MCU7T5V0__FILL_1
X113 VDD VSS GF180MCU_FD_SC_MCU7T5V0__FILLTIE
X114 _73_/I _23_/ZN VDD VDD VSS VSS GF180MCU_FD_SC_MCU7T5V0__CLKINV_1
X115 VDD VSS GF180MCU_FD_SC_MCU7T5V0__ENDCAP
X116 _88_/Z SW1[7] VDD VDD VSS VSS GF180MCU_FD_SC_MCU7T5V0__DLYB_1
X117 _77_/Z SW0[5] VDD VDD VSS VSS GF180MCU_FD_SC_MCU7T5V0__DLYB_1
X118 VDD VDD VSS VSS GF180MCU_FD_SC_MCU7T5V0__FILL_1
X119 VDD VDD VSS VSS GF180MCU_FD_SC_MCU7T5V0__FILL_2
X120 VDD VDD VSS VSS GF180MCU_FD_SC_MCU7T5V0__FILLCAP_4
X121 VDD VSS GF180MCU_FD_SC_MCU7T5V0__FILLTIE
X122 _72_/I _22_/ZN VDD VDD VSS VSS GF180MCU_FD_SC_MCU7T5V0__CLKINV_1
X123 _48_/I _50_/I VDD VDD VSS VSS GF180MCU_FD_SC_MCU7T5V0__DLYB_1
X124 VDD VSS GF180MCU_FD_SC_MCU7T5V0__ENDCAP
X125 VDD VSS GF180MCU_FD_SC_MCU7T5V0__FILLTIE
X126 _78_/Z SW0[6] VDD VDD VSS VSS GF180MCU_FD_SC_MCU7T5V0__DLYB_1
X127 VDD VDD VSS VSS GF180MCU_FD_SC_MCU7T5V0__FILL_1
X128 VDD VDD VSS VSS GF180MCU_FD_SC_MCU7T5V0__FILLCAP_4
X129 VDD VSS GF180MCU_FD_SC_MCU7T5V0__ENDCAP
X130 VDD VDD VSS VSS GF180MCU_FD_SC_MCU7T5V0__FILLCAP_4
X131 _49_/I _48_/I VDD VDD VSS VSS GF180MCU_FD_SC_MCU7T5V0__DLYB_1
X132 VDD VDD VSS VSS GF180MCU_FD_SC_MCU7T5V0__FILL_2
X133 VDD VDD VSS VSS GF180MCU_FD_SC_MCU7T5V0__FILLCAP_4
X134 VDD VDD VSS VSS GF180MCU_FD_SC_MCU7T5V0__FILL_2
X135 _60_/Q _21_/ZN VDD VDD VSS VSS GF180MCU_FD_SC_MCU7T5V0__CLKINV_1
X136 VDD VSS GF180MCU_FD_SC_MCU7T5V0__FILLTIE
X137 VDD VSS GF180MCU_FD_SC_MCU7T5V0__FILLTIE
X138 SAMP _49_/I VDD VDD VSS VSS GF180MCU_FD_SC_MCU7T5V0__DLYB_1
X139 VDD VSS GF180MCU_FD_SC_MCU7T5V0__ENDCAP
X140 VDD VDD VSS VSS GF180MCU_FD_SC_MCU7T5V0__FILL_2
X141 VDD VDD VSS VSS GF180MCU_FD_SC_MCU7T5V0__FILLCAP_4
X142 VDD VDD VSS VSS GF180MCU_FD_SC_MCU7T5V0__FILL_1
X143 VDD VDD VSS VSS GF180MCU_FD_SC_MCU7T5V0__FILL_2
X144 VDD VDD VSS VSS GF180MCU_FD_SC_MCU7T5V0__FILL_1
X145 Vcomp _60_/D VDD VDD VSS VSS GF180MCU_FD_SC_MCU7T5V0__DLYB_1
X146 _79_/I _79_/Z VDD VDD VSS VSS GF180MCU_FD_SC_MCU7T5V0__BUF_1
X147 VDD VDD VSS VSS GF180MCU_FD_SC_MCU7T5V0__FILL_2
X148 VDD VDD VSS VSS GF180MCU_FD_SC_MCU7T5V0__FILLCAP_8
X149 VDD VDD VSS VSS GF180MCU_FD_SC_MCU7T5V0__FILLCAP_8
X150 VDD VDD VSS VSS GF180MCU_FD_SC_MCU7T5V0__FILL_2
X151 VDD VSS GF180MCU_FD_SC_MCU7T5V0__ENDCAP
X152 VDD VDD VSS VSS GF180MCU_FD_SC_MCU7T5V0__FILLCAP_8
X153 VDD VDD VSS VSS GF180MCU_FD_SC_MCU7T5V0__FILLCAP_4
X154 _78_/I _78_/Z VDD VDD VSS VSS GF180MCU_FD_SC_MCU7T5V0__BUF_1
X155 VDD VSS GF180MCU_FD_SC_MCU7T5V0__ENDCAP
X156 VDD VSS GF180MCU_FD_SC_MCU7T5V0__ENDCAP
X157 VDD VDD VSS VSS GF180MCU_FD_SC_MCU7T5V0__FILL_2
X158 VDD VDD VSS VSS GF180MCU_FD_SC_MCU7T5V0__FILLCAP_4
X159 VDD VDD VSS VSS GF180MCU_FD_SC_MCU7T5V0__FILL_2
X160 VDD VDD VSS VSS GF180MCU_FD_SC_MCU7T5V0__FILLCAP_4
X161 _77_/I _77_/Z VDD VDD VSS VSS GF180MCU_FD_SC_MCU7T5V0__BUF_1
X162 VDD VDD VSS VSS GF180MCU_FD_SC_MCU7T5V0__FILLCAP_32
X163 VDD VSS GF180MCU_FD_SC_MCU7T5V0__FILLTIE
X164 VDD VSS GF180MCU_FD_SC_MCU7T5V0__FILLTIE
X165 VDD VDD VSS VSS GF180MCU_FD_SC_MCU7T5V0__FILLCAP_8
X166 VDD VDD VSS VSS GF180MCU_FD_SC_MCU7T5V0__FILLCAP_4
X167 _76_/I _76_/Z VDD VDD VSS VSS GF180MCU_FD_SC_MCU7T5V0__BUF_1
X168 VDD VDD VSS VSS GF180MCU_FD_SC_MCU7T5V0__FILLCAP_4
X169 VDD VSS GF180MCU_FD_SC_MCU7T5V0__FILLTIE
X170 _60_/D _59_/RN _81_/I _72_/I VDD VDD VSS VSS GF180MCU_FD_SC_MCU7T5V0__DFFRNQ_1
X171 VDD VSS GF180MCU_FD_SC_MCU7T5V0__FILLTIE
X172 _61_/D VDD VDD VSS VSS GF180MCU_FD_SC_MCU7T5V0__TIEH
X173 VDD VDD VSS VSS GF180MCU_FD_SC_MCU7T5V0__FILL_2
X174 VDD VDD VSS VSS GF180MCU_FD_SC_MCU7T5V0__FILLCAP_8
X175 VDD VDD VSS VSS GF180MCU_FD_SC_MCU7T5V0__FILLCAP_16
X176 VDD VSS GF180MCU_FD_SC_MCU7T5V0__ENDCAP
X177 _75_/I _75_/Z VDD VDD VSS VSS GF180MCU_FD_SC_MCU7T5V0__BUF_1
X178 _60_/D _58_/RN _82_/I _73_/I VDD VDD VSS VSS GF180MCU_FD_SC_MCU7T5V0__DFFRNQ_1
X179 VDD VDD VSS VSS GF180MCU_FD_SC_MCU7T5V0__FILLCAP_32
X180 VDD VDD VSS VSS GF180MCU_FD_SC_MCU7T5V0__FILLCAP_32
X181 VDD VSS GF180MCU_FD_SC_MCU7T5V0__ENDCAP
X182 VDD VDD VSS VSS GF180MCU_FD_SC_MCU7T5V0__FILL_2
X183 VDD VDD VSS VSS GF180MCU_FD_SC_MCU7T5V0__FILLCAP_8
X184 VDD VDD VSS VSS GF180MCU_FD_SC_MCU7T5V0__FILLCAP_8
X185 _74_/I _74_/Z VDD VDD VSS VSS GF180MCU_FD_SC_MCU7T5V0__BUF_1
X186 VDD VSS GF180MCU_FD_SC_MCU7T5V0__ENDCAP
X187 _60_/D _57_/RN _83_/I _74_/I VDD VDD VSS VSS GF180MCU_FD_SC_MCU7T5V0__DFFRNQ_1
X188 VDD VSS GF180MCU_FD_SC_MCU7T5V0__FILLTIE
X189 VDD VDD VSS VSS GF180MCU_FD_SC_MCU7T5V0__FILL_2
X190 VDD VSS GF180MCU_FD_SC_MCU7T5V0__FILLTIE
X191 _73_/I _73_/Z VDD VDD VSS VSS GF180MCU_FD_SC_MCU7T5V0__BUF_1
X192 _60_/D _56_/RN _84_/I _75_/I VDD VDD VSS VSS GF180MCU_FD_SC_MCU7T5V0__DFFRNQ_1
X193 VDD VDD VSS VSS GF180MCU_FD_SC_MCU7T5V0__FILL_2
X194 VDD VDD VSS VSS GF180MCU_FD_SC_MCU7T5V0__FILLCAP_16
X195 VDD VDD VSS VSS GF180MCU_FD_SC_MCU7T5V0__FILL_1
X196 _50_/I _69_/RN VDD VDD VSS VSS GF180MCU_FD_SC_MCU7T5V0__CLKINV_1
X197 VDD VSS GF180MCU_FD_SC_MCU7T5V0__FILLTIE
X198 VDD VSS GF180MCU_FD_SC_MCU7T5V0__FILLTIE
X199 _72_/I _72_/Z VDD VDD VSS VSS GF180MCU_FD_SC_MCU7T5V0__BUF_1
X200 VDD VDD VSS VSS GF180MCU_FD_SC_MCU7T5V0__FILLCAP_16
X201 VDD VSS GF180MCU_FD_SC_MCU7T5V0__ENDCAP
X202 _60_/D _55_/RN _85_/I _76_/I VDD VDD VSS VSS GF180MCU_FD_SC_MCU7T5V0__DFFRNQ_1
X203 VDD VDD VSS VSS GF180MCU_FD_SC_MCU7T5V0__FILL_1
X204 _50_/I _68_/RN VDD VDD VSS VSS GF180MCU_FD_SC_MCU7T5V0__CLKINV_1
X205 Vcomp VDD VDD VSS VSS GF180MCU_FD_SC_MCU7T5V0__ANTENNA
X206 VDD VDD VSS VSS GF180MCU_FD_SC_MCU7T5V0__FILLCAP_16
X207 VDD VSS GF180MCU_FD_SC_MCU7T5V0__ENDCAP
X208 VDD VSS GF180MCU_FD_SC_MCU7T5V0__FILLTIE
X209 _60_/D _54_/RN _86_/I _77_/I VDD VDD VSS VSS GF180MCU_FD_SC_MCU7T5V0__DFFRNQ_1
X210 VDD VDD VSS VSS GF180MCU_FD_SC_MCU7T5V0__FILL_1
X211 VDD VDD VSS VSS GF180MCU_FD_SC_MCU7T5V0__FILLCAP_16
X212 _50_/I _67_/RN VDD VDD VSS VSS GF180MCU_FD_SC_MCU7T5V0__CLKINV_1
X213 VDD VDD VSS VSS GF180MCU_FD_SC_MCU7T5V0__FILL_2
X214 VDD VSS GF180MCU_FD_SC_MCU7T5V0__ENDCAP
X215 VDD VDD VSS VSS GF180MCU_FD_SC_MCU7T5V0__FILLCAP_8
X216 VDD VSS GF180MCU_FD_SC_MCU7T5V0__FILLTIE
X217 _88_/I _70_/RN _70_/CLK _89_/I VDD VDD VSS VSS GF180MCU_FD_SC_MCU7T5V0__DFFRNQ_1
X218 VDD VSS GF180MCU_FD_SC_MCU7T5V0__ENDCAP
X219 CLK clkbuf_0_CLK/Z VDD VDD VSS VSS GF180MCU_FD_SC_MCU7T5V0__CLKBUF_16
X220 _60_/D _53_/RN _87_/I _78_/I VDD VDD VSS VSS GF180MCU_FD_SC_MCU7T5V0__DFFRNQ_1
X221 VDD VDD VSS VSS GF180MCU_FD_SC_MCU7T5V0__FILL_2
X222 VDD VDD VSS VSS GF180MCU_FD_SC_MCU7T5V0__FILLCAP_8
X223 VDD VSS GF180MCU_FD_SC_MCU7T5V0__ENDCAP
X224 _50_/I _66_/RN VDD VDD VSS VSS GF180MCU_FD_SC_MCU7T5V0__CLKINV_1
X225 VDD VDD VSS VSS GF180MCU_FD_SC_MCU7T5V0__FILLCAP_16
X226 VDD VSS GF180MCU_FD_SC_MCU7T5V0__FILLTIE
X227 _60_/D _52_/RN _88_/I _79_/I VDD VDD VSS VSS GF180MCU_FD_SC_MCU7T5V0__DFFRNQ_1
X228 VDD VDD VSS VSS GF180MCU_FD_SC_MCU7T5V0__FILLCAP_4
X229 VDD VSS GF180MCU_FD_SC_MCU7T5V0__FILLTIE
X230 _48_/I _65_/RN VDD VDD VSS VSS GF180MCU_FD_SC_MCU7T5V0__CLKINV_1
X231 VDD VDD VSS VSS GF180MCU_FD_SC_MCU7T5V0__FILLCAP_16
X232 VDD VDD VSS VSS GF180MCU_FD_SC_MCU7T5V0__FILL_1
X233 VDD VDD VSS VSS GF180MCU_FD_SC_MCU7T5V0__FILL_1
X234 VDD VSS GF180MCU_FD_SC_MCU7T5V0__FILLTIE
X235 VDD VDD VSS VSS GF180MCU_FD_SC_MCU7T5V0__FILL_1
X236 VDD VSS GF180MCU_FD_SC_MCU7T5V0__FILLTIE
X237 _60_/D _51_/RN _89_/I _80_/I VDD VDD VSS VSS GF180MCU_FD_SC_MCU7T5V0__DFFRNQ_1
X238 VDD VDD VSS VSS GF180MCU_FD_SC_MCU7T5V0__FILL_1
X239 _48_/I _64_/RN VDD VDD VSS VSS GF180MCU_FD_SC_MCU7T5V0__CLKINV_1
X240 CLK VDD VDD VSS VSS GF180MCU_FD_SC_MCU7T5V0__ANTENNA
X241 VDD VSS GF180MCU_FD_SC_MCU7T5V0__FILLTIE
X242 _50_/I _60_/RN VDD VDD VSS VSS GF180MCU_FD_SC_MCU7T5V0__CLKINV_1
X243 _50_/I _63_/RN VDD VDD VSS VSS GF180MCU_FD_SC_MCU7T5V0__CLKINV_1
X244 VDD VDD VSS VSS GF180MCU_FD_SC_MCU7T5V0__FILL_1
X245 VDD VDD VSS VSS GF180MCU_FD_SC_MCU7T5V0__FILLCAP_4
X246 VDD VSS GF180MCU_FD_SC_MCU7T5V0__ENDCAP
X247 VDD VDD VSS VSS GF180MCU_FD_SC_MCU7T5V0__FILL_1
X248 VDD VSS GF180MCU_FD_SC_MCU7T5V0__ENDCAP
X249 VDD VDD VSS VSS GF180MCU_FD_SC_MCU7T5V0__FILLCAP_8
X250 VDD VDD VSS VSS GF180MCU_FD_SC_MCU7T5V0__FILL_1
X251 VDD VDD VSS VSS GF180MCU_FD_SC_MCU7T5V0__FILL_2
X252 VDD VDD VSS VSS GF180MCU_FD_SC_MCU7T5V0__FILLCAP_4
X253 VDD VDD VSS VSS GF180MCU_FD_SC_MCU7T5V0__FILL_2
X254 VDD VDD VSS VSS GF180MCU_FD_SC_MCU7T5V0__FILL_2
X255 VDD VDD VSS VSS GF180MCU_FD_SC_MCU7T5V0__FILL_1
X256 VDD VSS GF180MCU_FD_SC_MCU7T5V0__FILLTIE
X257 _50_/I _62_/RN VDD VDD VSS VSS GF180MCU_FD_SC_MCU7T5V0__CLKINV_1
X258 VDD VDD VSS VSS GF180MCU_FD_SC_MCU7T5V0__FILLCAP_8
X259 VDD VDD VSS VSS GF180MCU_FD_SC_MCU7T5V0__FILL_1
X260 VDD VSS GF180MCU_FD_SC_MCU7T5V0__ENDCAP
X261 VDD VDD VSS VSS GF180MCU_FD_SC_MCU7T5V0__FILL_1
X262 VDD VDD VSS VSS GF180MCU_FD_SC_MCU7T5V0__FILLCAP_16
X263 _50_/I _61_/RN VDD VDD VSS VSS GF180MCU_FD_SC_MCU7T5V0__CLKINV_1
X264 VDD VDD VSS VSS GF180MCU_FD_SC_MCU7T5V0__FILLCAP_16
X265 VDD VDD VSS VSS GF180MCU_FD_SC_MCU7T5V0__FILLCAP_16
X266 VDD VDD VSS VSS GF180MCU_FD_SC_MCU7T5V0__FILL_1
X267 _80_/I _30_/ZN VDD VDD VSS VSS GF180MCU_FD_SC_MCU7T5V0__CLKINV_1
X268 VDD VSS GF180MCU_FD_SC_MCU7T5V0__ENDCAP
X269 VDD VDD VSS VSS GF180MCU_FD_SC_MCU7T5V0__FILLCAP_8
X270 VDD VDD VSS VSS GF180MCU_FD_SC_MCU7T5V0__FILLCAP_8
X271 VDD VDD VSS VSS GF180MCU_FD_SC_MCU7T5V0__FILLCAP_8
X272 VDD VDD VSS VSS GF180MCU_FD_SC_MCU7T5V0__FILLCAP_4
X273 VDD VDD VSS VSS GF180MCU_FD_SC_MCU7T5V0__FILL_2
X274 _89_/I _89_/Z VDD VDD VSS VSS GF180MCU_FD_SC_MCU7T5V0__BUF_1
X275 VDD VDD VSS VSS GF180MCU_FD_SC_MCU7T5V0__FILL_1
X276 VDD VSS GF180MCU_FD_SC_MCU7T5V0__ENDCAP
X277 VDD VSS GF180MCU_FD_SC_MCU7T5V0__ENDCAP
X278 _88_/I _88_/Z VDD VDD VSS VSS GF180MCU_FD_SC_MCU7T5V0__BUF_1
X279 VDD VDD VSS VSS GF180MCU_FD_SC_MCU7T5V0__FILLCAP_16
X280 VDD VDD VSS VSS GF180MCU_FD_SC_MCU7T5V0__FILLCAP_4
X281 VDD VDD VSS VSS GF180MCU_FD_SC_MCU7T5V0__FILL_1
X282 _87_/I _87_/Z VDD VDD VSS VSS GF180MCU_FD_SC_MCU7T5V0__BUF_1
X283 _21_/ZN B[0] VDD VDD VSS VSS GF180MCU_FD_SC_MCU7T5V0__DLYB_1
X284 _86_/I _86_/Z VDD VDD VSS VSS GF180MCU_FD_SC_MCU7T5V0__BUF_1
X285 VDD VDD VSS VSS GF180MCU_FD_SC_MCU7T5V0__FILL_1
X286 _87_/I _69_/RN _70_/CLK _88_/I VDD VDD VSS VSS GF180MCU_FD_SC_MCU7T5V0__DFFRNQ_1
X287 VDD VSS GF180MCU_FD_SC_MCU7T5V0__FILLTIE
X288 _22_/ZN B[1] VDD VDD VSS VSS GF180MCU_FD_SC_MCU7T5V0__DLYB_1
X289 VDD VDD VSS VSS GF180MCU_FD_SC_MCU7T5V0__FILLCAP_4
X290 VDD VDD VSS VSS GF180MCU_FD_SC_MCU7T5V0__FILLCAP_4
X291 VDD VDD VSS VSS GF180MCU_FD_SC_MCU7T5V0__FILLCAP_16
X292 VDD VDD VSS VSS GF180MCU_FD_SC_MCU7T5V0__FILLCAP_4
X293 _85_/I _85_/Z VDD VDD VSS VSS GF180MCU_FD_SC_MCU7T5V0__BUF_1
X294 VDD VSS GF180MCU_FD_SC_MCU7T5V0__ENDCAP
X295 _86_/I _68_/RN _68_/CLK _87_/I VDD VDD VSS VSS GF180MCU_FD_SC_MCU7T5V0__DFFRNQ_1
X296 VDD VDD VSS VSS GF180MCU_FD_SC_MCU7T5V0__FILL_2
X297 VDD VSS GF180MCU_FD_SC_MCU7T5V0__ENDCAP
X298 VDD VSS GF180MCU_FD_SC_MCU7T5V0__FILLTIE
X299 VDD VDD VSS VSS GF180MCU_FD_SC_MCU7T5V0__FILLCAP_4
X300 _23_/ZN B[2] VDD VDD VSS VSS GF180MCU_FD_SC_MCU7T5V0__DLYB_1
X301 clkbuf_0_CLK/Z _68_/CLK VDD VDD VSS VSS GF180MCU_FD_SC_MCU7T5V0__CLKBUF_16
X302 _84_/I _84_/Z VDD VDD VSS VSS GF180MCU_FD_SC_MCU7T5V0__BUF_1
X303 VDD VDD VSS VSS GF180MCU_FD_SC_MCU7T5V0__FILL_2
X304 VDD VDD VSS VSS GF180MCU_FD_SC_MCU7T5V0__FILLCAP_8
X305 VDD VDD VSS VSS GF180MCU_FD_SC_MCU7T5V0__FILL_1
X306 _85_/I _67_/RN _68_/CLK _86_/I VDD VDD VSS VSS GF180MCU_FD_SC_MCU7T5V0__DFFRNQ_1
X307 VDD VDD VSS VSS GF180MCU_FD_SC_MCU7T5V0__FILLCAP_4
X308 VDD VDD VSS VSS GF180MCU_FD_SC_MCU7T5V0__FILLCAP_32
X309 _24_/ZN B[3] VDD VDD VSS VSS GF180MCU_FD_SC_MCU7T5V0__DLYB_1
X310 _89_/Z SW1[8] VDD VDD VSS VSS GF180MCU_FD_SC_MCU7T5V0__DLYB_1
.ends sar_logic
