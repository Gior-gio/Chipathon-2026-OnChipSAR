* ==========================================
* LVS READY - MODULE: SAR_LOGIC
* ==========================================

.SUBCKT gf180mcu_fd_sc_mcu7t5v0__buf_1 I Z VDD VNW VPW VSS
X_i_2 VSS I Z_neg VPW nfet_05v0 W=3.6e-07 L=6e-07
X_i_0 Z Z_neg VSS VPW nfet_05v0 W=8.2e-07 L=6e-07
X_i_3 VDD I Z_neg VNW pfet_05v0 W=5.65e-07 L=5e-07
X_i_1 Z Z_neg VDD VNW pfet_05v0 W=1.22e-06 L=5e-07
.ENDS
.SUBCKT gf180mcu_fd_sc_mcu7t5v0__buf_2 I Z VDD VNW VPW VSS
X_i_2 VSS I Z_neg VPW nfet_05v0 W=8.2e-07 L=6e-07
X_i_0_0 Z Z_neg VSS VPW nfet_05v0 W=8.2e-07 L=6e-07
X_i_0_1 VSS Z_neg Z VPW nfet_05v0 W=8.2e-07 L=6e-07
X_i_3 VDD I Z_neg VNW pfet_05v0 W=1.22e-06 L=5e-07
X_i_1_0 Z Z_neg VDD VNW pfet_05v0 W=1.22e-06 L=5e-07
X_i_1_1 VDD Z_neg Z VNW pfet_05v0 W=1.22e-06 L=5e-07
.ENDS
.SUBCKT gf180mcu_fd_sc_mcu7t5v0__buf_3 I Z VDD VNW VPW VSS
X_i_2 VSS I Z_neg VPW nfet_05v0 W=8.2e-07 L=6e-07
X_i_0_0 Z Z_neg VSS VPW nfet_05v0 W=8.2e-07 L=6e-07
X_i_0_1 VSS Z_neg Z VPW nfet_05v0 W=8.2e-07 L=6e-07
X_i_0_2 Z Z_neg VSS VPW nfet_05v0 W=8.2e-07 L=6e-07
X_i_3 VDD I Z_neg VNW pfet_05v0 W=1.22e-06 L=5e-07
X_i_1_0 Z Z_neg VDD VNW pfet_05v0 W=1.22e-06 L=5e-07
X_i_1_1 VDD Z_neg Z VNW pfet_05v0 W=1.22e-06 L=5e-07
X_i_1_2 Z Z_neg VDD VNW pfet_05v0 W=1.22e-06 L=5e-07
.ENDS
.SUBCKT gf180mcu_fd_sc_mcu7t5v0__buf_4 I Z VDD VNW VPW VSS
X_i_2_0 Z_neg I VSS VPW nfet_05v0 W=8.2e-07 L=6e-07
X_i_2_1 VSS I Z_neg VPW nfet_05v0 W=8.2e-07 L=6e-07
X_i_0_0 Z Z_neg VSS VPW nfet_05v0 W=8.2e-07 L=6e-07
X_i_0_1 VSS Z_neg Z VPW nfet_05v0 W=8.2e-07 L=6e-07
X_i_0_2 Z Z_neg VSS VPW nfet_05v0 W=8.2e-07 L=6e-07
X_i_0_3 VSS Z_neg Z VPW nfet_05v0 W=8.2e-07 L=6e-07
X_i_3_0 Z_neg I VDD VNW pfet_05v0 W=1.22e-06 L=5e-07
X_i_3_1 VDD I Z_neg VNW pfet_05v0 W=1.22e-06 L=5e-07
X_i_1_0 Z Z_neg VDD VNW pfet_05v0 W=1.22e-06 L=5e-07
X_i_1_1 VDD Z_neg Z VNW pfet_05v0 W=1.22e-06 L=5e-07
X_i_1_2 Z Z_neg VDD VNW pfet_05v0 W=1.22e-06 L=5e-07
X_i_1_3 VDD Z_neg Z VNW pfet_05v0 W=1.22e-06 L=5e-07
.ENDS
.SUBCKT gf180mcu_fd_sc_mcu7t5v0__clkbuf_1 I Z VDD VNW VPW VSS
X_i_2 VSS I Z_neg VPW nfet_05v0 W=3.6e-07 L=6e-07
X_i_0 Z Z_neg VSS VPW nfet_05v0 W=4.95e-07 L=6e-07
* The device in the netlist is split in half, suggesting a two-fingered
* FET, which this is not.  Modified by Tim E. Nov. 3, 2025 to properly
* match the layout.
* M_i_3 VDD I Z_neg VNW pfet_05v0 W=5.25e-07 L=5e-07
* M_i_3_0 VDD I Z_neg VNW pfet_05v0 W=5.25e-07 L=5e-07
X_i_3 VDD I Z_neg VNW pfet_05v0 W=1.05e-06 L=5e-07
X_i_1 Z Z_neg VDD VNW pfet_05v0 W=1.22e-06 L=5e-07
.ENDS
.SUBCKT gf180mcu_fd_sc_mcu7t5v0__clkbuf_16 I Z VDD VNW VPW VSS
X_i_2_0 Z_neg I VSS VPW nfet_05v0 W=4.05e-07 L=6e-07
X_i_2_1 VSS I Z_neg VPW nfet_05v0 W=4.05e-07 L=6e-07
X_i_2_2 Z_neg I VSS VPW nfet_05v0 W=4.05e-07 L=6e-07
X_i_2_3 VSS I Z_neg VPW nfet_05v0 W=4.05e-07 L=6e-07
X_i_2_4 Z_neg I VSS VPW nfet_05v0 W=4.05e-07 L=6e-07
X_i_2_5 VSS I Z_neg VPW nfet_05v0 W=4.05e-07 L=6e-07
X_i_0_0 Z Z_neg VSS VPW nfet_05v0 W=4.85e-07 L=6e-07
X_i_0_1 VSS Z_neg Z VPW nfet_05v0 W=4.85e-07 L=6e-07
X_i_0_2 Z Z_neg VSS VPW nfet_05v0 W=4.85e-07 L=6e-07
X_i_0_3 VSS Z_neg Z VPW nfet_05v0 W=4.85e-07 L=6e-07
X_i_0_4 Z Z_neg VSS VPW nfet_05v0 W=4.85e-07 L=6e-07
X_i_0_5 VSS Z_neg Z VPW nfet_05v0 W=4.85e-07 L=6e-07
X_i_0_6 Z Z_neg VSS VPW nfet_05v0 W=4.85e-07 L=6e-07
X_i_0_7 VSS Z_neg Z VPW nfet_05v0 W=4.85e-07 L=6e-07
X_i_0_8 Z Z_neg VSS VPW nfet_05v0 W=4.85e-07 L=6e-07
X_i_0_9 VSS Z_neg Z VPW nfet_05v0 W=4.85e-07 L=6e-07
X_i_0_10 Z Z_neg VSS VPW nfet_05v0 W=4.85e-07 L=6e-07
X_i_0_11 VSS Z_neg Z VPW nfet_05v0 W=4.85e-07 L=6e-07
X_i_0_12 Z Z_neg VSS VPW nfet_05v0 W=4.85e-07 L=6e-07
X_i_0_13 VSS Z_neg Z VPW nfet_05v0 W=4.85e-07 L=6e-07
X_i_0_14 Z Z_neg VSS VPW nfet_05v0 W=4.85e-07 L=6e-07
X_i_0_15 VSS Z_neg Z VPW nfet_05v0 W=4.85e-07 L=6e-07
X_i_3_0 Z_neg I VDD VNW pfet_05v0 W=0.82e-06 L=5e-07
X_i_3_1 VDD I Z_neg VNW pfet_05v0 W=0.82e-06 L=5e-07
X_i_3_2 Z_neg I VDD VNW pfet_05v0 W=0.82e-06 L=5e-07
X_i_3_3 VDD I Z_neg VNW pfet_05v0 W=0.82e-06 L=5e-07
X_i_3_4 Z_neg I VDD VNW pfet_05v0 W=0.82e-06 L=5e-07
X_i_3_5 VDD I Z_neg VNW pfet_05v0 W=0.82e-06 L=5e-07
X_i_3_6 Z_neg I VDD VNW pfet_05v0 W=0.82e-06 L=5e-07
X_i_3_7 VDD I Z_neg VNW pfet_05v0 W=0.82e-06 L=5e-07
X_i_1_0 Z Z_neg VDD VNW pfet_05v0 W=1.22e-06 L=5e-07
X_i_1_1 VDD Z_neg Z VNW pfet_05v0 W=1.22e-06 L=5e-07
X_i_1_2 Z Z_neg VDD VNW pfet_05v0 W=1.22e-06 L=5e-07
X_i_1_3 VDD Z_neg Z VNW pfet_05v0 W=1.22e-06 L=5e-07
X_i_1_4 Z Z_neg VDD VNW pfet_05v0 W=1.22e-06 L=5e-07
X_i_1_5 VDD Z_neg Z VNW pfet_05v0 W=1.22e-06 L=5e-07
X_i_1_6 Z Z_neg VDD VNW pfet_05v0 W=1.22e-06 L=5e-07
X_i_1_7 VDD Z_neg Z VNW pfet_05v0 W=1.22e-06 L=5e-07
X_i_1_8 Z Z_neg VDD VNW pfet_05v0 W=1.22e-06 L=5e-07
X_i_1_9 VDD Z_neg Z VNW pfet_05v0 W=1.22e-06 L=5e-07
X_i_1_10 Z Z_neg VDD VNW pfet_05v0 W=1.22e-06 L=5e-07
X_i_1_11 VDD Z_neg Z VNW pfet_05v0 W=1.22e-06 L=5e-07
X_i_1_12 Z Z_neg VDD VNW pfet_05v0 W=1.22e-06 L=5e-07
X_i_1_13 VDD Z_neg Z VNW pfet_05v0 W=1.22e-06 L=5e-07
X_i_1_14 Z Z_neg VDD VNW pfet_05v0 W=1.22e-06 L=5e-07
X_i_1_15 VDD Z_neg Z VNW pfet_05v0 W=1.22e-06 L=5e-07
.ENDS
.SUBCKT gf180mcu_fd_sc_mcu7t5v0__clkinv_1 I ZN VDD VNW VPW VSS
X_i_0 ZN I VSS VPW nfet_05v0 W=4.8e-07 L=6e-07
X_i_1 ZN I VDD VNW pfet_05v0 W=1.22e-06 L=5e-07
.ENDS
.SUBCKT gf180mcu_fd_sc_mcu7t5v0__dffrnq_1 D RN CLK Q VDD VNW VPW VSS
X_tn10 ncki CLK VSS VPW nfet_05v0 W=4.05e-07 L=6e-07
X_tn13 cki ncki VSS VPW nfet_05v0 W=4.05e-07 L=6e-07
X_tn11 net10 D VSS VPW nfet_05v0 W=3.6e-07 L=6e-07
X_tn15 net10 ncki net1 VPW nfet_05v0 W=3.6e-07 L=6e-07
X_tn14 net1 cki net15 VPW nfet_05v0 W=3.6e-07 L=6e-07
X_tn8 net12 net2 net15 VPW nfet_05v0 W=3.6e-07 L=6e-07
X_tn9 VSS RN net12 VPW nfet_05v0 W=3.6e-07 L=6e-07
X_tn18 VSS net1 net2 VPW nfet_05v0 W=3.6e-07 L=6e-07
X_tn0 net8 cki net2 VPW nfet_05v0 W=3.6e-07 L=6e-07
X_tn1 net11 ncki net8 VPW nfet_05v0 W=3.6e-07 L=6e-07
X_tn12 net11 net4 VSS VPW nfet_05v0 W=3.6e-07 L=6e-07
X_tn5 net0 RN VSS VPW nfet_05v0 W=3.6e-07 L=6e-07
X_tn4 net4 net8 net0 VPW nfet_05v0 W=4e-07 L=6e-07
X_tn3 Q net4 VSS VPW nfet_05v0 W=8.15e-07 L=6e-07
X_tp8 ncki CLK VDD VNW pfet_05v0 W=8.65e-07 L=5e-07
X_tp11 cki ncki VDD VNW pfet_05v0 W=8.65e-07 L=5e-07
X_tp9 VDD D net10 VNW pfet_05v0 W=7.8e-07 L=5e-07
X_tp15 net1 cki net10 VNW pfet_05v0 W=7.8e-07 L=5e-07
X_tp7 net9 ncki net1 VNW pfet_05v0 W=7.8e-07 L=5e-07
X_tp6 VDD net2 net9 VNW pfet_05v0 W=7.8e-07 L=5e-07
X_tp12 net9 RN VDD VNW pfet_05v0 W=7.8e-07 L=5e-07
X_tp18 VDD net1 net2 VNW pfet_05v0 W=5.05e-07 L=5e-07
X_tp2 net2 ncki net8 VNW pfet_05v0 W=5.05e-07 L=5e-07
X_tp3 net8 cki net11 VNW pfet_05v0 W=5.05e-07 L=5e-07
X_tp10 net11 net4 VDD VNW pfet_05v0 W=5.05e-07 L=5e-07
X_tp5 net4 RN VDD VNW pfet_05v0 W=1e-06 L=5e-07
X_tp4 VDD net8 net4 VNW pfet_05v0 W=1e-06 L=5e-07
X_tp1 Q net4 VDD VNW pfet_05v0 W=1.215e-06 L=5e-07
.ENDS
.SUBCKT gf180mcu_fd_sc_mcu7t5v0__dffrnq_2 D RN CLK Q VDD VNW VPW VSS
X_tn10 ncki CLK VSS VPW nfet_05v0 W=4.05e-07 L=6e-07
X_tn13 cki ncki VSS VPW nfet_05v0 W=4.05e-07 L=6e-07
X_tn11 net10 D VSS VPW nfet_05v0 W=3.6e-07 L=6e-07
X_tn15 net10 ncki net1 VPW nfet_05v0 W=3.6e-07 L=6e-07
X_tn14 net1 cki net15 VPW nfet_05v0 W=3.6e-07 L=6e-07
X_tn8 net12 net2 net15 VPW nfet_05v0 W=3.6e-07 L=6e-07
X_tn9 VSS RN net12 VPW nfet_05v0 W=3.6e-07 L=6e-07
X_tn18 VSS net1 net2 VPW nfet_05v0 W=3.6e-07 L=6e-07
X_tn0 net8 cki net2 VPW nfet_05v0 W=3.6e-07 L=6e-07
X_tn1 net11 ncki net8 VPW nfet_05v0 W=3.6e-07 L=6e-07
X_tn12 net11 net4 VSS VPW nfet_05v0 W=3.6e-07 L=6e-07
X_tn5 net0 RN VSS VPW nfet_05v0 W=3.6e-07 L=6e-07
X_tn4 net4 net8 net0 VPW nfet_05v0 W=8.15e-07 L=6e-07
X_tn3_15 Q net4 VSS VPW nfet_05v0 W=8.15e-07 L=6e-07
X_tn3 Q net4 VSS VPW nfet_05v0 W=8.15e-07 L=6e-07
X_tp8 ncki CLK VDD VNW pfet_05v0 W=8.65e-07 L=5e-07
X_tp11 cki ncki VDD VNW pfet_05v0 W=8.65e-07 L=5e-07
X_tp9 VDD D net10 VNW pfet_05v0 W=7.8e-07 L=5e-07
X_tp15 net1 cki net10 VNW pfet_05v0 W=7.8e-07 L=5e-07
X_tp7 net9 ncki net1 VNW pfet_05v0 W=7.8e-07 L=5e-07
X_tp6 VDD net2 net9 VNW pfet_05v0 W=7.8e-07 L=5e-07
X_tp12 net9 RN VDD VNW pfet_05v0 W=7.8e-07 L=5e-07
X_tp18 VDD net1 net2 VNW pfet_05v0 W=5.05e-07 L=5e-07
X_tp2 net2 ncki net8 VNW pfet_05v0 W=5.05e-07 L=5e-07
X_tp3 net8 cki net11 VNW pfet_05v0 W=5.05e-07 L=5e-07
X_tp10 net11 net4 VDD VNW pfet_05v0 W=5.05e-07 L=5e-07
X_tp5 net4 RN VDD VNW pfet_05v0 W=1.215e-06 L=5e-07
X_tp4 VDD net8 net4 VNW pfet_05v0 W=1.215e-06 L=5e-07
X_tp1_13 Q net4 VDD VNW pfet_05v0 W=1.215e-06 L=5e-07
X_tp1 Q net4 VDD VNW pfet_05v0 W=1.215e-06 L=5e-07
.ENDS
.SUBCKT gf180mcu_fd_sc_mcu7t5v0__dffrsnq_1 D RN SETN CLK Q VDD VNW VPW VSS
X_tn1 ncki CLK VSS VPW nfet_05v0 W=4.05e-07 L=6e-07
X_tn2 cki ncki VSS VPW nfet_05v0 W=4.05e-07 L=6e-07
X_tn0 net14 D VSS VPW nfet_05v0 W=3.65e-07 L=6e-07
X_tn8 net14 ncki net3 VPW nfet_05v0 W=3.65e-07 L=6e-07
X_tn5 net3 cki net16 VPW nfet_05v0 W=3.65e-07 L=6e-07
X_tn6 net15 net4 net16 VPW nfet_05v0 W=3.65e-07 L=6e-07
X_tn7 VSS RN net15 VPW nfet_05v0 W=3.65e-07 L=6e-07
X_tn4 net0 net3 VSS VPW nfet_05v0 W=5.05e-07 L=6e-07
X_tn3 net4 SETN net0 VPW nfet_05v0 W=5.05e-07 L=6e-07
X_tn14 net5 cki net4 VPW nfet_05v0 W=5.05e-07 L=6e-07
X_tn13 net7 ncki net5 VPW nfet_05v0 W=5.05e-07 L=6e-07
X_tn15 net1 SETN net7 VPW nfet_05v0 W=3.8e-07 L=6e-07
X_tn16 VSS net6 net1 VPW nfet_05v0 W=3.8e-07 L=6e-07
X_tn18 net2 RN VSS VPW nfet_05v0 W=3.8e-07 L=6e-07
X_tn17 net6 net5 net2 VPW nfet_05v0 W=3.8e-07 L=6e-07
X_tn19 Q net6 VSS VPW nfet_05v0 W=8.15e-07 L=6e-07
X_tp1 ncki CLK VDD VNW pfet_05v0 W=8.65e-07 L=5e-07
X_tp2 cki ncki VDD VNW pfet_05v0 W=8.65e-07 L=5e-07
X_tp0 VDD D net14 VNW pfet_05v0 W=3.65e-07 L=5e-07
X_tp10 net3 cki net14 VNW pfet_05v0 W=3.65e-07 L=5e-07
X_tp7 net13 ncki net3 VNW pfet_05v0 W=3.65e-07 L=5e-07
X_tp5 VDD net4 net13 VNW pfet_05v0 W=3.65e-07 L=5e-07
X_tp6 net13 RN VDD VNW pfet_05v0 W=7.55e-07 L=5e-07
X_tp4 VDD net3 net4 VNW pfet_05v0 W=7.55e-07 L=5e-07
X_tp3 VDD SETN net4 VNW pfet_05v0 W=3.6e-07 L=5e-07
X_tp20 net4 ncki net5 VNW pfet_05v0 W=3.6e-07 L=5e-07
X_tp19 net5 cki net7 VNW pfet_05v0 W=3.6e-07 L=5e-07
X_tp13 net7 SETN VDD VNW pfet_05v0 W=7.7e-07 L=5e-07
X_tp14 net7 net6 VDD VNW pfet_05v0 W=7.7e-07 L=5e-07
X_tp16 net6 RN VDD VNW pfet_05v0 W=7.7e-07 L=5e-07
X_tp15 VDD net5 net6 VNW pfet_05v0 W=7.7e-07 L=5e-07
X_tp17 Q net6 VDD VNW pfet_05v0 W=1.215e-06 L=5e-07
.ENDS
.SUBCKT gf180mcu_fd_sc_mcu7t5v0__dffrsnq_2 D RN SETN CLK Q VDD VNW VPW VSS
X_tn1 ncki CLK VSS VPW nfet_05v0 W=4.05e-07 L=6e-07
X_tn2 cki ncki VSS VPW nfet_05v0 W=4.05e-07 L=6e-07
X_tn0 net14 D VSS VPW nfet_05v0 W=3.65e-07 L=6e-07
X_tn8 net14 ncki net3 VPW nfet_05v0 W=3.65e-07 L=6e-07
X_tn5 net3 cki net16 VPW nfet_05v0 W=3.65e-07 L=6e-07
X_tn6 net15 net4 net16 VPW nfet_05v0 W=3.65e-07 L=6e-07
X_tn7 VSS RN net15 VPW nfet_05v0 W=3.65e-07 L=6e-07
X_tn4 net0 net3 VSS VPW nfet_05v0 W=5.05e-07 L=6e-07
X_tn3 net4 SETN net0 VPW nfet_05v0 W=5.05e-07 L=6e-07
X_tn14 net5 cki net4 VPW nfet_05v0 W=5.05e-07 L=6e-07
X_tn13 net7 ncki net5 VPW nfet_05v0 W=5.05e-07 L=6e-07
X_tn15 net1 SETN net7 VPW nfet_05v0 W=3.8e-07 L=6e-07
X_tn16 VSS net6 net1 VPW nfet_05v0 W=3.8e-07 L=6e-07
X_tn18 net2 RN VSS VPW nfet_05v0 W=3.8e-07 L=6e-07
X_tn17 net6 net5 net2 VPW nfet_05v0 W=3.8e-07 L=6e-07
X_tn19_39 Q net6 VSS VPW nfet_05v0 W=8.15e-07 L=6e-07
X_tn19 Q net6 VSS VPW nfet_05v0 W=8.15e-07 L=6e-07
X_tp1 ncki CLK VDD VNW pfet_05v0 W=8.65e-07 L=5e-07
X_tp2 cki ncki VDD VNW pfet_05v0 W=8.65e-07 L=5e-07
X_tp0 VDD D net14 VNW pfet_05v0 W=3.65e-07 L=5e-07
X_tp10 net3 cki net14 VNW pfet_05v0 W=3.65e-07 L=5e-07
X_tp7 net13 ncki net3 VNW pfet_05v0 W=3.65e-07 L=5e-07
X_tp5 VDD net4 net13 VNW pfet_05v0 W=3.65e-07 L=5e-07
X_tp6 net13 RN VDD VNW pfet_05v0 W=7.55e-07 L=5e-07
X_tp4 VDD net3 net4 VNW pfet_05v0 W=7.55e-07 L=5e-07
X_tp3 VDD SETN net4 VNW pfet_05v0 W=3.6e-07 L=5e-07
X_tp20 net4 ncki net5 VNW pfet_05v0 W=3.6e-07 L=5e-07
X_tp19 net5 cki net7 VNW pfet_05v0 W=3.6e-07 L=5e-07
X_tp13 net7 SETN VDD VNW pfet_05v0 W=7.7e-07 L=5e-07
X_tp14 net7 net6 VDD VNW pfet_05v0 W=7.7e-07 L=5e-07
X_tp16 net6 RN VDD VNW pfet_05v0 W=7.7e-07 L=5e-07
X_tp15 VDD net5 net6 VNW pfet_05v0 W=7.7e-07 L=5e-07
X_tp17_33 Q net6 VDD VNW pfet_05v0 W=1.215e-06 L=5e-07
X_tp17 Q net6 VDD VNW pfet_05v0 W=1.215e-06 L=5e-07
.ENDS
.SUBCKT gf180mcu_fd_sc_mcu7t5v0__dlyb_1 I Z VDD VNW VPW VSS
X_i_2_0 Z_neg I VSS VPW nfet_05v0 W=3.6e-07 L=6e-07
X_i_2 net_2 Z_neg net_1 VPW nfet_05v0 W=3.6e-07 L=6e-07
X_i_3 net_1 Z_neg VSS VPW nfet_05v0 W=3.6e-07 L=6e-07
X_i_2_21 net_3 net_2 net_6 VPW nfet_05v0 W=3.65e-07 L=0.600000U
X_i_3_6 net_6 net_2 VSS VPW nfet_05v0 W=3.65e-07 L=6e-07
X_i_2_0_18 Z net_3 VSS VPW nfet_05v0 W=8.2e-07 L=6e-07
X_i_3_0 Z_neg I VDD VNW pfet_05v0 W=3.6e-07 L=5e-07
X_i_0 net_0 Z_neg VDD VNW pfet_05v0 W=3.6e-07 L=5e-07
X_i_1 net_2 Z_neg net_0 VNW pfet_05v0 W=3.6e-07 L=5e-07
X_i_0_29 net_5 net_2 VDD VNW pfet_05v0 W=3.6e-07 L=5e-07
X_i_1_39 net_3 net_2 net_5 VNW pfet_05v0 W=3.6e-07 L=5e-07
X_i_3_0_0 Z net_3 VDD VNW pfet_05v0 W=1.22e-06 L=5e-07
.ENDS
.SUBCKT gf180mcu_fd_sc_mcu7t5v0__dlyc_1 I Z VDD VNW VPW VSS
X_i_2_0 Z_neg I VSS VPW nfet_05v0 W=3.6e-07 L=6e-07
X_i_2 net_7 Z_neg net_1 VPW nfet_05v0 W=3.6e-07 L=6e-07
X_i_3 net_1 Z_neg VSS VPW nfet_05v0 W=3.6e-07 L=6e-07
X_i_2_26 net_9 net_7 net_13 VPW nfet_05v0 W=3.6e-07 L=6e-07
X_i_3_30 net_13 net_7 VSS VPW nfet_05v0 W=3.6e-07 L=6e-07
X_i_2_0_1 net_8 net_9 net_11 VPW nfet_05v0 W=3.6e-07 L=6e-07
X_i_3_4 net_11 net_9 VSS VPW nfet_05v0 W=3.6e-07 L=6e-07
X_i_2_21 net_3 net_8 net_6 VPW nfet_05v0 W=3.65e-07 L=6e-07
X_i_3_6 net_6 net_8 VSS VPW nfet_05v0 W=3.65e-07 L=6e-07
X_i_2_0_18 Z net_3 VSS VPW nfet_05v0 W=8.2e-07 L=6e-07
X_i_3_0 Z_neg I VDD VNW pfet_05v0 W=3.6e-07 L=5e-07
X_i_0 net_0 Z_neg VDD VNW pfet_05v0 W=3.6e-07 L=5e-07
X_i_1 net_7 Z_neg net_0 VNW pfet_05v0 W=3.6e-07 L=5e-07
X_i_0_35 net_12 net_7 VDD VNW pfet_05v0 W=3.6e-07 L=5e-07
X_i_1_47 net_9 net_7 net_12 VNW pfet_05v0 W=3.6e-07 L=5e-07
X_i_0_9 net_10 net_9 VDD VNW pfet_05v0 W=3.6e-07 L=5e-07
X_i_1_22 net_8 net_9 net_10 VNW pfet_05v0 W=3.6e-07 L=5e-07
X_i_0_29 net_5 net_8 VDD VNW pfet_05v0 W=3.6e-07 L=5e-07
X_i_1_39 net_3 net_8 net_5 VNW pfet_05v0 W=3.6e-07 L=5e-07
X_i_3_0_0 Z net_3 VDD VNW pfet_05v0 W=1.22e-06 L=5e-07
.ENDS
.SUBCKT gf180mcu_fd_sc_mcu7t5v0__endcap VDD VSS
.ENDS
.SUBCKT gf180mcu_fd_sc_mcu7t5v0__fill_1 VDD VNW VPW VSS
.ENDS
.SUBCKT gf180mcu_fd_sc_mcu7t5v0__fill_2 VDD VNW VPW VSS
.ENDS
.SUBCKT gf180mcu_fd_sc_mcu7t5v0__fillcap_4 VDD VNW VPW VSS
X_i_17 net_1 net_0 VSS VPW nfet_05v0 W=8.2e-07 L=1e-06
X_i_19 VDD net_1 net_0 VNW pfet_05v0 W=1.22e-06 L=1e-06
.ENDS
.SUBCKT gf180mcu_fd_sc_mcu7t5v0__fillcap_8 VDD VNW VPW VSS
X_i_17 net_3 net_2 VSS VPW nfet_05v0 W=8.2e-07 L=1e-06
X_i_17_23 net_4 net_5 VSS VPW nfet_05v0 W=8.2e-07 L=1e-06
X_i_19 VDD net_3 net_2 VNW pfet_05v0 W=1.22e-06 L=1e-06
X_i_19_7 VDD net_4 net_5 VNW pfet_05v0 W=1.22e-06 L=1e-06
.ENDS
.SUBCKT gf180mcu_fd_sc_mcu7t5v0__fillcap_16 VDD VNW VPW VSS
X_i_17 net_3 net_2 VSS VPW nfet_05v0 W=8.2e-07 L=1e-06
X_i_17_23 net_4 net_5 VSS VPW nfet_05v0 W=8.2e-07 L=1e-06
X_i_17_24 net_7 net_9 VSS VPW nfet_05v0 W=8.2e-07 L=1e-06
X_i_17_23_55 net_6 net_8 VSS VPW nfet_05v0 W=8.2e-07 L=1e-06
X_i_19 VDD net_3 net_2 VNW pfet_05v0 W=1.22e-06 L=1e-06
X_i_19_7 VDD net_4 net_5 VNW pfet_05v0 W=1.22e-06 L=1e-06
X_i_19_33 VDD net_7 net_9 VNW pfet_05v0 W=1.22e-06 L=1e-06
X_i_19_7_23 VDD net_6 net_8 VNW pfet_05v0 W=1.22e-06 L=1e-06
.ENDS
.SUBCKT gf180mcu_fd_sc_mcu7t5v0__fillcap_32 VDD VNW VPW VSS
X_i_17 net_3 net_2 VSS VPW nfet_05v0 W=8.2e-07 L=1e-06
X_i_17_23 net_4 net_5 VSS VPW nfet_05v0 W=8.2e-07 L=1e-06
X_i_17_24 net_7 net_9 VSS VPW nfet_05v0 W=8.2e-07 L=1e-06
X_i_17_23_55 net_6 net_8 VSS VPW nfet_05v0 W=8.2e-07 L=1e-06
X_i_17_27 net_17 net_14 VSS VPW nfet_05v0 W=8.2e-07 L=1e-06
X_i_17_23_63 net_16 net_15 VSS VPW nfet_05v0 W=8.2e-07 L=1e-06
X_i_17_24_22 net_13 net_11 VSS VPW nfet_05v0 W=8.2e-07 L=1e-06
X_i_17_23_55_93 net_12 net_10 VSS VPW nfet_05v0 W=8.2e-07 L=1e-06
X_i_19 VDD net_3 net_2 VNW pfet_05v0 W=1.22e-06 L=1e-06
X_i_19_7 VDD net_4 net_5 VNW pfet_05v0 W=1.22e-06 L=1e-06
X_i_19_33 VDD net_7 net_9 VNW pfet_05v0 W=1.22e-06 L=1e-06
X_i_19_7_23 VDD net_6 net_8 VNW pfet_05v0 W=1.22e-06 L=1e-06
X_i_19_94 VDD net_17 net_14 VNW pfet_05v0 W=1.22e-06 L=1e-06
X_i_19_7_87 VDD net_16 net_15 VNW pfet_05v0 W=1.22e-06 L=1e-06
X_i_19_33_95 VDD net_13 net_11 VNW pfet_05v0 W=1.22e-06 L=1e-06
X_i_19_7_23_23 VDD net_12 net_10 VNW pfet_05v0 W=1.22e-06 L=1e-06
.ENDS
.SUBCKT gf180mcu_fd_sc_mcu7t5v0__filltie VDD VSS
.ENDS
.SUBCKT gf180mcu_fd_sc_mcu7t5v0__inv_2 I ZN VDD VNW VPW VSS
X_i_0_0 ZN I VSS VPW nfet_05v0 W=8.2e-07 L=6e-07
X_i_0_1 VSS I ZN VPW nfet_05v0 W=8.2e-07 L=6e-07
X_i_1_0 ZN I VDD VNW pfet_05v0 W=1.22e-06 L=5e-07
X_i_1_1 VDD I ZN VNW pfet_05v0 W=1.22e-06 L=5e-07
.ENDS
.SUBCKT gf180mcu_fd_sc_mcu7t5v0__mux2_2 I0 I1 S Z VDD VNW VPW VSS
X_MN2_12 VSS int04 Z VPW nfet_05v0 W=8.2e-07 L=6e-07
X_MN2 VSS int04 Z VPW nfet_05v0 W=8.2e-07 L=6e-07
X_MN4 net_1 I1 VSS VPW nfet_05v0 W=8.2e-07 L=6e-07
X_MN8 int04 S net_1 VPW nfet_05v0 W=8.2e-07 L=6e-07
X_MN7 net_3 sel1_n int04 VPW nfet_05v0 W=8.2e-07 L=6e-07
X_MN3 VSS I0 net_3 VPW nfet_05v0 W=8.2e-07 L=6e-07
X_MN1 sel1_n S VSS VPW nfet_05v0 W=8.2e-07 L=6e-07
X_MP5_6 VDD int04 Z VNW pfet_05v0 W=1.22e-06 L=5e-07
X_MP5 VDD int04 Z VNW pfet_05v0 W=1.22e-06 L=5e-07
X_MP4 net_0 I1 VDD VNW pfet_05v0 W=1.22e-06 L=5e-07
X_MP8 int04 sel1_n net_0 VNW pfet_05v0 W=1.22e-06 L=5e-07
X_MP7 net_2 S int04 VNW pfet_05v0 W=1.22e-06 L=5e-07
X_MP3 VDD I0 net_2 VNW pfet_05v0 W=1.22e-06 L=5e-07
X_MP1 sel1_n S VDD VNW pfet_05v0 W=1.22e-06 L=5e-07
.ENDS
.SUBCKT gf180mcu_fd_sc_mcu7t5v0__nand2_1 A1 A2 ZN VDD VNW VPW VSS
X_i_1 net_0 A2 VSS VPW nfet_05v0 W=8.2e-07 L=6e-07
X_i_0 ZN A1 net_0 VPW nfet_05v0 W=8.2e-07 L=6e-07
X_i_3 ZN A2 VDD VNW pfet_05v0 W=1.13e-06 L=5e-07
X_i_2 VDD A1 ZN VNW pfet_05v0 W=1.13e-06 L=5e-07
.ENDS
.SUBCKT gf180mcu_fd_sc_mcu7t5v0__nor2_1 A1 A2 ZN VDD VNW VPW VSS
X_i_1 ZN A2 VSS VPW nfet_05v0 W=5.65e-07 L=6e-07
X_i_0 VSS A1 ZN VPW nfet_05v0 W=5.65e-07 L=6e-07
X_i_3 net_0 A2 VDD VNW pfet_05v0 W=1.22e-06 L=5e-07
X_i_2 ZN A1 net_0 VNW pfet_05v0 W=1.22e-06 L=5e-07
.ENDS
.SUBCKT gf180mcu_fd_sc_mcu7t5v0__or2_1 A1 A2 Z VDD VNW VPW VSS
X_i_2 Z_neg A1 VSS VPW nfet_05v0 W=3.6e-07 L=6e-07
X_i_3 VSS A2 Z_neg VPW nfet_05v0 W=3.6e-07 L=6e-07
X_i_0 Z Z_neg VSS VPW nfet_05v0 W=8.2e-07 L=6e-07
X_i_4 net_0 A1 Z_neg VNW pfet_05v0 W=5.65e-07 L=5e-07
X_i_5 VDD A2 net_0 VNW pfet_05v0 W=5.65e-07 L=5e-07
X_i_1 Z Z_neg VDD VNW pfet_05v0 W=1.22e-06 L=5e-07
.ENDS
.SUBCKT gf180mcu_fd_sc_mcu7t5v0__tieh Z VDD VNW VPW VSS
X_n_tran_1 VSS A A VPW nfet_05v0 W=0.82U L=0.600000U
X_p_tran_2 VDD A Z VNW pfet_05v0 W=1.22e-06 L=5e-07
.ENDS

* --- DIGITAL DESIGN ---
.subckt sar_logic B[0] B[1] B[2] B[3] B[4] B[5] B[6] B[7] B[8] B[9] CLK SAMP SW0n[0]
+ SW0n[1] SW0n[2] SW0n[3] SW0n[4] SW0n[5] SW0n[6] SW0n[7] SW0n[8] SW0p[0] SW0p[1]
+ SW0p[2] SW0p[3] SW0p[4] SW0p[5] SW0p[6] SW0p[7] SW0p[8] SW1n[0] SW1n[1] SW1n[2]
+ SW1n[3] SW1n[4] SW1n[5] SW1n[6] SW1n[7] SW1n[8] SW1p[0] SW1p[1] SW1p[2] SW1p[3]
+ SW1p[4] SW1p[5] SW1p[6] SW1p[7] SW1p[8] VDD VSS Vcomp eoc
X1 VDD VDD VSS VSS GF180MCU_FD_SC_MCU7T5V0__FILL_1
X2 VDD VDD VSS VSS GF180MCU_FD_SC_MCU7T5V0__FILL_1
X3 VDD VDD VSS VSS GF180MCU_FD_SC_MCU7T5V0__FILL_2
X4 _131_/D _131_/RN _119_/Z _142_/CLK _154_/I VDD VDD VSS VSS GF180MCU_FD_SC_MCU7T5V0__DFFRSNQ_2
X5 _062_/I _062_/ZN VDD VDD VSS VSS GF180MCU_FD_SC_MCU7T5V0__CLKINV_1
X6 _143_/D VDD VDD VSS VSS GF180MCU_FD_SC_MCU7T5V0__TIEH
X7 _122_/I wire55/I _114_/Z VDD VDD VSS VSS GF180MCU_FD_SC_MCU7T5V0__OR2_1
X8 VDD VSS GF180MCU_FD_SC_MCU7T5V0__FILLTIE
X9 wire77/Z SW0n[7] VDD VDD VSS VSS GF180MCU_FD_SC_MCU7T5V0__CLKBUF_1
X10 _163_/Z SW1n[0] VDD VDD VSS VSS GF180MCU_FD_SC_MCU7T5V0__BUF_1
X11 _174_/Z SW1p[2] VDD VDD VSS VSS GF180MCU_FD_SC_MCU7T5V0__BUF_1
X12 _062_/ZN B[4] VDD VDD VSS VSS GF180MCU_FD_SC_MCU7T5V0__BUF_1
X13 VDD VDD VSS VSS GF180MCU_FD_SC_MCU7T5V0__FILL_1
X14 _130_/D _130_/RN _118_/Z _143_/CLK _155_/I VDD VDD VSS VSS GF180MCU_FD_SC_MCU7T5V0__DFFRSNQ_2
X15 VDD VSS GF180MCU_FD_SC_MCU7T5V0__ENDCAP
X16 VDD VDD VSS VSS GF180MCU_FD_SC_MCU7T5V0__FILLCAP_8
X17 _061_/I _061_/ZN VDD VDD VSS VSS GF180MCU_FD_SC_MCU7T5V0__CLKINV_1
X18 VDD VDD VSS VSS GF180MCU_FD_SC_MCU7T5V0__FILL_1
X19 VDD VDD VSS VSS GF180MCU_FD_SC_MCU7T5V0__FILLCAP_4
X20 _109_/I wire55/I _113_/Z VDD VDD VSS VSS GF180MCU_FD_SC_MCU7T5V0__OR2_1
X21 VDD VSS GF180MCU_FD_SC_MCU7T5V0__FILLTIE
X22 VDD VSS GF180MCU_FD_SC_MCU7T5V0__ENDCAP
X23 _065_/ZN B[7] VDD VDD VSS VSS GF180MCU_FD_SC_MCU7T5V0__BUF_1
X24 _092_/I1 SW0n[8] VDD VDD VSS VSS GF180MCU_FD_SC_MCU7T5V0__CLKBUF_1
X25 _164_/Z SW1n[1] VDD VDD VSS VSS GF180MCU_FD_SC_MCU7T5V0__BUF_4
X26 _175_/Z SW1p[3] VDD VDD VSS VSS GF180MCU_FD_SC_MCU7T5V0__BUF_4
X27 _063_/ZN B[5] VDD VDD VSS VSS GF180MCU_FD_SC_MCU7T5V0__BUF_1
X28 VDD VDD VSS VSS GF180MCU_FD_SC_MCU7T5V0__FILL_2
X29 VDD VDD VSS VSS GF180MCU_FD_SC_MCU7T5V0__FILL_1
X30 VDD VDD VSS VSS GF180MCU_FD_SC_MCU7T5V0__FILL_1
X31 VDD VDD VSS VSS GF180MCU_FD_SC_MCU7T5V0__FILL_1
X32 VDD VDD VSS VSS GF180MCU_FD_SC_MCU7T5V0__FILL_2
X33 _060_/I _060_/ZN VDD VDD VSS VSS GF180MCU_FD_SC_MCU7T5V0__CLKINV_1
X34 _109_/I _142_/D _112_/Z VDD VDD VSS VSS GF180MCU_FD_SC_MCU7T5V0__OR2_1
X35 VDD VSS GF180MCU_FD_SC_MCU7T5V0__ENDCAP
X36 SAMP input1/I VDD VDD VSS VSS GF180MCU_FD_SC_MCU7T5V0__DLYC_1
X37 VDD VDD VSS VSS GF180MCU_FD_SC_MCU7T5V0__FILL_2
X38 _066_/ZN B[8] VDD VDD VSS VSS GF180MCU_FD_SC_MCU7T5V0__BUF_1
X39 _154_/Z SW0p[0] VDD VDD VSS VSS GF180MCU_FD_SC_MCU7T5V0__BUF_4
X40 _069_/I SW1n[2] VDD VDD VSS VSS GF180MCU_FD_SC_MCU7T5V0__BUF_1
X41 _070_/I SW1p[4] VDD VDD VSS VSS GF180MCU_FD_SC_MCU7T5V0__CLKBUF_1
X42 _064_/ZN B[6] VDD VDD VSS VSS GF180MCU_FD_SC_MCU7T5V0__BUF_1
X43 VDD VSS GF180MCU_FD_SC_MCU7T5V0__FILLTIE
X44 VDD VDD VSS VSS GF180MCU_FD_SC_MCU7T5V0__FILLCAP_4
X45 VDD VSS GF180MCU_FD_SC_MCU7T5V0__ENDCAP
X46 VDD VDD VSS VSS GF180MCU_FD_SC_MCU7T5V0__FILLCAP_4
X47 _122_/I _143_/RN VDD VDD VSS VSS GF180MCU_FD_SC_MCU7T5V0__CLKINV_1
X48 VDD VDD VSS VSS GF180MCU_FD_SC_MCU7T5V0__FILL_1
X49 VDD VDD VSS VSS GF180MCU_FD_SC_MCU7T5V0__FILL_1
X50 _067_/ZN B[9] VDD VDD VSS VSS GF180MCU_FD_SC_MCU7T5V0__BUF_1
X51 _155_/Z SW0p[1] VDD VDD VSS VSS GF180MCU_FD_SC_MCU7T5V0__BUF_4
X52 _166_/Z SW1n[3] VDD VDD VSS VSS GF180MCU_FD_SC_MCU7T5V0__BUF_1
X53 _085_/A1 SW1p[5] VDD VDD VSS VSS GF180MCU_FD_SC_MCU7T5V0__CLKBUF_1
X54 VDD VSS GF180MCU_FD_SC_MCU7T5V0__FILLTIE
X55 VDD VDD VSS VSS GF180MCU_FD_SC_MCU7T5V0__FILL_1
X56 VDD VDD VSS VSS GF180MCU_FD_SC_MCU7T5V0__FILL_2
X57 VDD VDD VSS VSS GF180MCU_FD_SC_MCU7T5V0__FILLCAP_32
X58 VDD VDD VSS VSS GF180MCU_FD_SC_MCU7T5V0__FILL_1
X59 _142_/CLK clkload0/ZN VDD VDD VSS VSS GF180MCU_FD_SC_MCU7T5V0__INV_2
X60 _110_/I _142_/RN VDD VDD VSS VSS GF180MCU_FD_SC_MCU7T5V0__CLKINV_1
X61 VDD VDD VSS VSS GF180MCU_FD_SC_MCU7T5V0__FILLCAP_4
X62 _059_/I SW0n[0] VDD VDD VSS VSS GF180MCU_FD_SC_MCU7T5V0__CLKBUF_1
X63 _156_/Z SW0p[2] VDD VDD VSS VSS GF180MCU_FD_SC_MCU7T5V0__BUF_4
X64 _167_/Z SW1n[4] VDD VDD VSS VSS GF180MCU_FD_SC_MCU7T5V0__BUF_1
X65 _071_/I SW1p[6] VDD VDD VSS VSS GF180MCU_FD_SC_MCU7T5V0__CLKBUF_1
X66 VDD VSS GF180MCU_FD_SC_MCU7T5V0__FILLTIE
X67 clkbuf_0_CLK/Z _142_/CLK VDD VDD VSS VSS GF180MCU_FD_SC_MCU7T5V0__CLKBUF_16
X68 VDD VDD VSS VSS GF180MCU_FD_SC_MCU7T5V0__FILL_1
X69 VDD VDD VSS VSS GF180MCU_FD_SC_MCU7T5V0__FILL_2
X70 VDD VDD VSS VSS GF180MCU_FD_SC_MCU7T5V0__FILL_2
X71 _169_/I _169_/Z VDD VDD VSS VSS GF180MCU_FD_SC_MCU7T5V0__BUF_4
X72 VDD VDD VSS VSS GF180MCU_FD_SC_MCU7T5V0__FILLCAP_4
X73 _060_/I SW0n[1] VDD VDD VSS VSS GF180MCU_FD_SC_MCU7T5V0__CLKBUF_1
X74 _157_/Z SW0p[3] VDD VDD VSS VSS GF180MCU_FD_SC_MCU7T5V0__BUF_4
X75 _168_/Z SW1n[5] VDD VDD VSS VSS GF180MCU_FD_SC_MCU7T5V0__BUF_1
X76 _089_/A1 SW1p[7] VDD VDD VSS VSS GF180MCU_FD_SC_MCU7T5V0__CLKBUF_1
X77 VDD VDD VSS VSS GF180MCU_FD_SC_MCU7T5V0__FILL_1
X78 VDD VDD VSS VSS GF180MCU_FD_SC_MCU7T5V0__FILL_2
X79 VDD VSS GF180MCU_FD_SC_MCU7T5V0__ENDCAP
X80 _168_/I _168_/Z VDD VDD VSS VSS GF180MCU_FD_SC_MCU7T5V0__BUF_4
X81 _122_/I _126_/RN VDD VDD VSS VSS GF180MCU_FD_SC_MCU7T5V0__CLKINV_1
X82 VDD VDD VSS VSS GF180MCU_FD_SC_MCU7T5V0__FILLCAP_8
X83 VDD VSS GF180MCU_FD_SC_MCU7T5V0__ENDCAP
X84 _061_/I SW0n[2] VDD VDD VSS VSS GF180MCU_FD_SC_MCU7T5V0__CLKBUF_1
X85 _158_/Z SW0p[4] VDD VDD VSS VSS GF180MCU_FD_SC_MCU7T5V0__BUF_4
X86 _169_/Z SW1n[6] VDD VDD VSS VSS GF180MCU_FD_SC_MCU7T5V0__BUF_1
X87 _180_/Z SW1p[8] VDD VDD VSS VSS GF180MCU_FD_SC_MCU7T5V0__BUF_1
X88 VDD VSS GF180MCU_FD_SC_MCU7T5V0__ENDCAP
X89 VDD VSS GF180MCU_FD_SC_MCU7T5V0__FILLTIE
X90 VDD VDD VSS VSS GF180MCU_FD_SC_MCU7T5V0__FILL_1
X91 VDD VDD VSS VSS GF180MCU_FD_SC_MCU7T5V0__FILL_1
X92 VDD VSS GF180MCU_FD_SC_MCU7T5V0__FILLTIE
X93 _167_/I _167_/Z VDD VDD VSS VSS GF180MCU_FD_SC_MCU7T5V0__BUF_4
X94 _121_/I _127_/RN VDD VDD VSS VSS GF180MCU_FD_SC_MCU7T5V0__CLKINV_1
X95 _062_/I SW0n[3] VDD VDD VSS VSS GF180MCU_FD_SC_MCU7T5V0__CLKBUF_1
X96 _159_/Z SW0p[5] VDD VDD VSS VSS GF180MCU_FD_SC_MCU7T5V0__BUF_4
X97 _170_/Z SW1n[7] VDD VDD VSS VSS GF180MCU_FD_SC_MCU7T5V0__BUF_4
X98 _133_/Q eoc VDD VDD VSS VSS GF180MCU_FD_SC_MCU7T5V0__BUF_1
X99 _088_/I0 _086_/I1 VDD VDD VSS VSS GF180MCU_FD_SC_MCU7T5V0__CLKBUF_1
X100 VDD VSS GF180MCU_FD_SC_MCU7T5V0__FILLTIE
X101 VDD VDD VSS VSS GF180MCU_FD_SC_MCU7T5V0__FILL_1
X102 VDD VDD VSS VSS GF180MCU_FD_SC_MCU7T5V0__FILL_1
X103 VDD VSS GF180MCU_FD_SC_MCU7T5V0__FILLTIE
X104 VDD VDD VSS VSS GF180MCU_FD_SC_MCU7T5V0__FILL_2
X105 VDD VDD VSS VSS GF180MCU_FD_SC_MCU7T5V0__FILL_1
X106 _166_/I _166_/Z VDD VDD VSS VSS GF180MCU_FD_SC_MCU7T5V0__BUF_1
X107 _121_/I _128_/RN VDD VDD VSS VSS GF180MCU_FD_SC_MCU7T5V0__CLKINV_1
X108 _063_/I SW0n[4] VDD VDD VSS VSS GF180MCU_FD_SC_MCU7T5V0__CLKBUF_1
X109 _160_/Z SW0p[6] VDD VDD VSS VSS GF180MCU_FD_SC_MCU7T5V0__BUF_4
X110 _171_/Z SW1n[8] VDD VDD VSS VSS GF180MCU_FD_SC_MCU7T5V0__BUF_4
X111 _154_/I _059_/I VDD VDD VSS VSS GF180MCU_FD_SC_MCU7T5V0__BUF_4
X112 wire82/Z _088_/I0 VDD VDD VSS VSS GF180MCU_FD_SC_MCU7T5V0__CLKBUF_1
X113 VDD VSS GF180MCU_FD_SC_MCU7T5V0__FILLTIE
X114 _122_/I _129_/RN VDD VDD VSS VSS GF180MCU_FD_SC_MCU7T5V0__CLKINV_1
X115 VDD VDD VSS VSS GF180MCU_FD_SC_MCU7T5V0__FILL_1
X116 VDD VDD VSS VSS GF180MCU_FD_SC_MCU7T5V0__FILL_2
X117 VDD VDD VSS VSS GF180MCU_FD_SC_MCU7T5V0__FILLCAP_4
X118 _086_/I0 SW0n[5] VDD VDD VSS VSS GF180MCU_FD_SC_MCU7T5V0__CLKBUF_1
X119 _161_/Z SW0p[7] VDD VDD VSS VSS GF180MCU_FD_SC_MCU7T5V0__BUF_4
X120 _079_/A1 _175_/I _080_/S VDD VDD VSS VSS GF180MCU_FD_SC_MCU7T5V0__NAND2_1
X121 _141_/Q _170_/I VDD VDD VSS VSS GF180MCU_FD_SC_MCU7T5V0__BUF_4
X122 VDD VDD VSS VSS GF180MCU_FD_SC_MCU7T5V0__FILLCAP_4
X123 VDD VSS GF180MCU_FD_SC_MCU7T5V0__ENDCAP
X124 VDD VSS GF180MCU_FD_SC_MCU7T5V0__FILLTIE
X125 VDD VDD VSS VSS GF180MCU_FD_SC_MCU7T5V0__FILL_1
X126 _164_/I _164_/Z VDD VDD VSS VSS GF180MCU_FD_SC_MCU7T5V0__BUF_4
X127 _122_/I _130_/RN VDD VDD VSS VSS GF180MCU_FD_SC_MCU7T5V0__CLKINV_1
X128 _060_/I _086_/I1 _078_/S _130_/D VDD VDD VSS VSS GF180MCU_FD_SC_MCU7T5V0__MUX2_2
X129 VDD VSS GF180MCU_FD_SC_MCU7T5V0__ENDCAP
X130 _088_/I1 SW0n[6] VDD VDD VSS VSS GF180MCU_FD_SC_MCU7T5V0__CLKBUF_1
X131 _169_/I _071_/I VDD VDD VSS VSS GF180MCU_FD_SC_MCU7T5V0__BUF_4
X132 _109_/I _122_/I VDD VDD VSS VSS GF180MCU_FD_SC_MCU7T5V0__BUF_2
X133 VDD VSS GF180MCU_FD_SC_MCU7T5V0__ENDCAP
X134 _180_/I _180_/Z VDD VDD VSS VSS GF180MCU_FD_SC_MCU7T5V0__CLKBUF_1
X135 VDD VSS GF180MCU_FD_SC_MCU7T5V0__FILLTIE
X136 VDD VDD VSS VSS GF180MCU_FD_SC_MCU7T5V0__FILLCAP_4
X137 _163_/I _163_/Z VDD VDD VSS VSS GF180MCU_FD_SC_MCU7T5V0__BUF_1
X138 _121_/I _131_/RN VDD VDD VSS VSS GF180MCU_FD_SC_MCU7T5V0__CLKINV_1
X139 VDD VDD VSS VSS GF180MCU_FD_SC_MCU7T5V0__FILL_1
X140 VDD VDD VSS VSS GF180MCU_FD_SC_MCU7T5V0__FILL_2
X141 _164_/I _079_/A1 wire53/I VDD VDD VSS VSS GF180MCU_FD_SC_MCU7T5V0__NOR2_1
X142 _121_/I _109_/I VDD VDD VSS VSS GF180MCU_FD_SC_MCU7T5V0__BUF_4
X143 _129_/D _129_/RN _117_/Z _143_/CLK _156_/I VDD VDD VSS VSS GF180MCU_FD_SC_MCU7T5V0__DFFRSNQ_2
X144 VDD VDD VSS VSS GF180MCU_FD_SC_MCU7T5V0__FILL_1
X145 VDD VSS GF180MCU_FD_SC_MCU7T5V0__FILLTIE
X146 VDD VSS GF180MCU_FD_SC_MCU7T5V0__FILLTIE
X147 VDD VDD VSS VSS GF180MCU_FD_SC_MCU7T5V0__FILL_1
X148 _162_/I _162_/Z VDD VDD VSS VSS GF180MCU_FD_SC_MCU7T5V0__BUF_4
X149 _109_/I _142_/D _093_/Z VDD VDD VSS VSS GF180MCU_FD_SC_MCU7T5V0__OR2_1
X150 input1/I _110_/I VDD VDD VSS VSS GF180MCU_FD_SC_MCU7T5V0__BUF_3
X151 VDD VDD VSS VSS GF180MCU_FD_SC_MCU7T5V0__FILL_2
X152 _082_/I1 _154_/I _076_/S _131_/D VDD VDD VSS VSS GF180MCU_FD_SC_MCU7T5V0__MUX2_2
X153 _168_/I _085_/A1 VDD VDD VSS VSS GF180MCU_FD_SC_MCU7T5V0__BUF_4
X154 _158_/I _063_/I VDD VDD VSS VSS GF180MCU_FD_SC_MCU7T5V0__BUF_4
X155 _110_/I _121_/I VDD VDD VSS VSS GF180MCU_FD_SC_MCU7T5V0__BUF_2
X156 _128_/D _128_/RN _116_/Z _142_/CLK _157_/I VDD VDD VSS VSS GF180MCU_FD_SC_MCU7T5V0__DFFRSNQ_2
X157 _059_/I _059_/ZN VDD VDD VSS VSS GF180MCU_FD_SC_MCU7T5V0__CLKINV_1
X158 VDD VDD VSS VSS GF180MCU_FD_SC_MCU7T5V0__FILL_1
X159 VDD VSS GF180MCU_FD_SC_MCU7T5V0__ENDCAP
X160 VDD VSS GF180MCU_FD_SC_MCU7T5V0__FILLTIE
X161 VDD VSS GF180MCU_FD_SC_MCU7T5V0__FILLTIE
X162 VDD VDD VSS VSS GF180MCU_FD_SC_MCU7T5V0__FILL_2
X163 _161_/I _161_/Z VDD VDD VSS VSS GF180MCU_FD_SC_MCU7T5V0__BUF_4
X164 wire82/I _092_/I1 _092_/S _123_/D VDD VDD VSS VSS GF180MCU_FD_SC_MCU7T5V0__MUX2_2
X165 VDD VDD VSS VSS GF180MCU_FD_SC_MCU7T5V0__FILL_1
X166 Vcomp wire82/I VDD VDD VSS VSS GF180MCU_FD_SC_MCU7T5V0__BUF_1
X167 VDD VDD VSS VSS GF180MCU_FD_SC_MCU7T5V0__FILLCAP_4
X168 VDD VDD VSS VSS GF180MCU_FD_SC_MCU7T5V0__FILL_1
X169 _075_/A1 _173_/I _076_/S VDD VDD VSS VSS GF180MCU_FD_SC_MCU7T5V0__NAND2_1
X170 _167_/I _070_/I VDD VDD VSS VSS GF180MCU_FD_SC_MCU7T5V0__BUF_4
X171 _159_/I _086_/I0 VDD VDD VSS VSS GF180MCU_FD_SC_MCU7T5V0__BUF_4
X172 _127_/D _127_/RN _115_/Z _142_/CLK _158_/I VDD VDD VSS VSS GF180MCU_FD_SC_MCU7T5V0__DFFRSNQ_2
X173 _132_/Q _058_/ZN VDD VDD VSS VSS GF180MCU_FD_SC_MCU7T5V0__CLKINV_1
X174 VDD VDD VSS VSS GF180MCU_FD_SC_MCU7T5V0__FILL_1
X175 VDD VSS GF180MCU_FD_SC_MCU7T5V0__ENDCAP
X176 _160_/I _160_/Z VDD VDD VSS VSS GF180MCU_FD_SC_MCU7T5V0__BUF_4
X177 _091_/A1 _142_/D _092_/S VDD VDD VSS VSS GF180MCU_FD_SC_MCU7T5V0__NAND2_1
X178 VDD VDD VSS VSS GF180MCU_FD_SC_MCU7T5V0__FILLCAP_4
X179 VDD VSS GF180MCU_FD_SC_MCU7T5V0__FILLTIE
X180 _143_/D _143_/RN _143_/CLK _143_/Q VDD VDD VSS VSS GF180MCU_FD_SC_MCU7T5V0__DFFRNQ_1
X181 _132_/Q _082_/I1 _074_/S _132_/D VDD VDD VSS VSS GF180MCU_FD_SC_MCU7T5V0__MUX2_2
X182 VDD VSS GF180MCU_FD_SC_MCU7T5V0__FILLTIE
X183 VDD VDD VSS VSS GF180MCU_FD_SC_MCU7T5V0__FILLCAP_8
X184 _160_/I _088_/I1 VDD VDD VSS VSS GF180MCU_FD_SC_MCU7T5V0__BUF_4
X185 _126_/D _126_/RN _114_/Z _143_/CLK _159_/I VDD VDD VSS VSS GF180MCU_FD_SC_MCU7T5V0__DFFRSNQ_2
X186 _122_/I _132_/RN VDD VDD VSS VSS GF180MCU_FD_SC_MCU7T5V0__CLKINV_1
X187 VDD VSS GF180MCU_FD_SC_MCU7T5V0__ENDCAP
X188 VDD VSS GF180MCU_FD_SC_MCU7T5V0__ENDCAP
X189 VDD VDD VSS VSS GF180MCU_FD_SC_MCU7T5V0__FILL_1
X190 _109_/I _141_/RN VDD VDD VSS VSS GF180MCU_FD_SC_MCU7T5V0__CLKINV_1
X191 VDD VDD VSS VSS GF180MCU_FD_SC_MCU7T5V0__FILLCAP_4
X192 VDD VDD VSS VSS GF180MCU_FD_SC_MCU7T5V0__FILL_2
X193 VDD VDD VSS VSS GF180MCU_FD_SC_MCU7T5V0__FILL_1
X194 wire77/Z wire82/Z _090_/S _124_/D VDD VDD VSS VSS GF180MCU_FD_SC_MCU7T5V0__MUX2_2
X195 VDD VSS GF180MCU_FD_SC_MCU7T5V0__FILLTIE
X196 _142_/D _142_/RN _142_/CLK _180_/I VDD VDD VSS VSS GF180MCU_FD_SC_MCU7T5V0__DFFRNQ_2
X197 VDD VSS GF180MCU_FD_SC_MCU7T5V0__FILLTIE
X198 _075_/A1 _133_/Q wire54/I VDD VDD VSS VSS GF180MCU_FD_SC_MCU7T5V0__NOR2_1
X199 _166_/I _175_/I VDD VDD VSS VSS GF180MCU_FD_SC_MCU7T5V0__BUF_4
X200 _125_/D _125_/RN _113_/Z _143_/CLK _160_/I VDD VDD VSS VSS GF180MCU_FD_SC_MCU7T5V0__DFFRSNQ_2
X201 _109_/I _140_/RN VDD VDD VSS VSS GF180MCU_FD_SC_MCU7T5V0__CLKINV_1
X202 VDD VSS GF180MCU_FD_SC_MCU7T5V0__FILLTIE
X203 VDD VDD VSS VSS GF180MCU_FD_SC_MCU7T5V0__FILLCAP_8
X204 _171_/I _141_/RN _143_/CLK _141_/Q VDD VDD VSS VSS GF180MCU_FD_SC_MCU7T5V0__DFFRNQ_2
X205 _180_/I _091_/A1 VDD VDD VSS VSS GF180MCU_FD_SC_MCU7T5V0__CLKINV_1
X206 VDD VSS GF180MCU_FD_SC_MCU7T5V0__FILLTIE
X207 wire55/I _119_/A2 VDD VDD VSS VSS GF180MCU_FD_SC_MCU7T5V0__CLKBUF_1
X208 _174_/I _069_/I VDD VDD VSS VSS GF180MCU_FD_SC_MCU7T5V0__BUF_4
X209 _162_/I _092_/I1 VDD VDD VSS VSS GF180MCU_FD_SC_MCU7T5V0__BUF_4
X210 _124_/D _124_/RN _112_/Z _142_/CLK _161_/I VDD VDD VSS VSS GF180MCU_FD_SC_MCU7T5V0__DFFRSNQ_2
X211 _109_/I _139_/RN VDD VDD VSS VSS GF180MCU_FD_SC_MCU7T5V0__CLKINV_1
X212 VDD VDD VSS VSS GF180MCU_FD_SC_MCU7T5V0__FILL_1
X213 VDD VDD VSS VSS GF180MCU_FD_SC_MCU7T5V0__FILL_2
X214 _170_/I _140_/RN _143_/CLK _169_/I VDD VDD VSS VSS GF180MCU_FD_SC_MCU7T5V0__DFFRNQ_2
X215 _071_/I _087_/A1 VDD VDD VSS VSS GF180MCU_FD_SC_MCU7T5V0__CLKINV_1
X216 VDD VSS GF180MCU_FD_SC_MCU7T5V0__ENDCAP
X217 VDD VDD VSS VSS GF180MCU_FD_SC_MCU7T5V0__FILLCAP_4
X218 _143_/Q wire55/I VDD VDD VSS VSS GF180MCU_FD_SC_MCU7T5V0__CLKBUF_1
X219 wire82/Z _082_/I1 VDD VDD VSS VSS GF180MCU_FD_SC_MCU7T5V0__CLKBUF_1
X220 _123_/D _123_/RN _093_/Z _142_/CLK _162_/I VDD VDD VSS VSS GF180MCU_FD_SC_MCU7T5V0__DFFRSNQ_2
X221 VDD VDD VSS VSS GF180MCU_FD_SC_MCU7T5V0__FILL_2
X222 _109_/I _138_/RN VDD VDD VSS VSS GF180MCU_FD_SC_MCU7T5V0__CLKINV_1
X223 VDD VDD VSS VSS GF180MCU_FD_SC_MCU7T5V0__FILL_1
X224 VDD VSS GF180MCU_FD_SC_MCU7T5V0__ENDCAP
X225 VDD VDD VSS VSS GF180MCU_FD_SC_MCU7T5V0__FILL_2
X226 VDD VDD VSS VSS GF180MCU_FD_SC_MCU7T5V0__FILL_2
X227 VDD VSS GF180MCU_FD_SC_MCU7T5V0__FILLTIE
X228 VDD VDD VSS VSS GF180MCU_FD_SC_MCU7T5V0__FILL_1
X229 _070_/I _083_/A1 VDD VDD VSS VSS GF180MCU_FD_SC_MCU7T5V0__CLKINV_1
X230 _180_/I _171_/I VDD VDD VSS VSS GF180MCU_FD_SC_MCU7T5V0__BUF_4
X231 VDD VSS GF180MCU_FD_SC_MCU7T5V0__FILLTIE
X232 _122_/I _134_/RN VDD VDD VSS VSS GF180MCU_FD_SC_MCU7T5V0__CLKINV_1
X233 VDD VSS GF180MCU_FD_SC_MCU7T5V0__FILLTIE
X234 VDD VSS GF180MCU_FD_SC_MCU7T5V0__ENDCAP
X235 _109_/I _137_/RN VDD VDD VSS VSS GF180MCU_FD_SC_MCU7T5V0__CLKINV_1
X236 VDD VDD VSS VSS GF180MCU_FD_SC_MCU7T5V0__FILL_1
X237 VDD VSS GF180MCU_FD_SC_MCU7T5V0__FILLTIE
X238 VDD VDD VSS VSS GF180MCU_FD_SC_MCU7T5V0__FILL_1
X239 VDD VDD VSS VSS GF180MCU_FD_SC_MCU7T5V0__FILLCAP_4
X240 _141_/Q _089_/A1 VDD VDD VSS VSS GF180MCU_FD_SC_MCU7T5V0__BUF_4
X241 _121_/I _133_/RN VDD VDD VSS VSS GF180MCU_FD_SC_MCU7T5V0__CLKINV_1
X242 VDD VSS GF180MCU_FD_SC_MCU7T5V0__FILLTIE
X243 VDD VSS GF180MCU_FD_SC_MCU7T5V0__FILLTIE
X244 _121_/I _136_/RN VDD VDD VSS VSS GF180MCU_FD_SC_MCU7T5V0__CLKINV_1
X245 VDD VDD VSS VSS GF180MCU_FD_SC_MCU7T5V0__FILL_2
X246 VDD VDD VSS VSS GF180MCU_FD_SC_MCU7T5V0__FILL_1
X247 VDD VSS GF180MCU_FD_SC_MCU7T5V0__ENDCAP
X248 _122_/I _143_/Q _120_/Z VDD VDD VSS VSS GF180MCU_FD_SC_MCU7T5V0__OR2_1
X249 _121_/I _135_/RN VDD VDD VSS VSS GF180MCU_FD_SC_MCU7T5V0__CLKINV_1
X250 VDD VSS GF180MCU_FD_SC_MCU7T5V0__FILLTIE
X251 VDD VSS GF180MCU_FD_SC_MCU7T5V0__ENDCAP
X252 VDD VDD VSS VSS GF180MCU_FD_SC_MCU7T5V0__FILL_1
X253 VDD VDD VSS VSS GF180MCU_FD_SC_MCU7T5V0__FILL_2
X254 VDD VDD VSS VSS GF180MCU_FD_SC_MCU7T5V0__FILLCAP_4
X255 VDD VDD VSS VSS GF180MCU_FD_SC_MCU7T5V0__FILL_1
X256 _109_/I _123_/RN VDD VDD VSS VSS GF180MCU_FD_SC_MCU7T5V0__CLKINV_1
X257 VDD VDD VSS VSS GF180MCU_FD_SC_MCU7T5V0__FILL_2
X258 VDD VDD VSS VSS GF180MCU_FD_SC_MCU7T5V0__FILL_1
X259 VDD VSS GF180MCU_FD_SC_MCU7T5V0__ENDCAP
X260 VDD VSS GF180MCU_FD_SC_MCU7T5V0__FILLTIE
X261 VDD VSS GF180MCU_FD_SC_MCU7T5V0__ENDCAP
X262 CLK clkbuf_0_CLK/Z VDD VDD VSS VSS GF180MCU_FD_SC_MCU7T5V0__CLKBUF_16
X263 VDD VDD VSS VSS GF180MCU_FD_SC_MCU7T5V0__FILLCAP_8
X264 _155_/I _060_/I VDD VDD VSS VSS GF180MCU_FD_SC_MCU7T5V0__BUF_4
X265 wire82/I wire82/Z VDD VDD VSS VSS GF180MCU_FD_SC_MCU7T5V0__CLKBUF_1
X266 _121_/I _124_/RN VDD VDD VSS VSS GF180MCU_FD_SC_MCU7T5V0__CLKINV_1
X267 VDD VSS GF180MCU_FD_SC_MCU7T5V0__ENDCAP
X268 VDD VDD VSS VSS GF180MCU_FD_SC_MCU7T5V0__FILL_2
X269 VDD VDD VSS VSS GF180MCU_FD_SC_MCU7T5V0__FILLCAP_8
X270 VDD VSS GF180MCU_FD_SC_MCU7T5V0__FILLTIE
X271 VDD VDD VSS VSS GF180MCU_FD_SC_MCU7T5V0__FILL_1
X272 VDD VDD VSS VSS GF180MCU_FD_SC_MCU7T5V0__FILL_1
X273 wire50/I _090_/S VDD VDD VSS VSS GF180MCU_FD_SC_MCU7T5V0__DLYB_1
X274 _156_/I _061_/I VDD VDD VSS VSS GF180MCU_FD_SC_MCU7T5V0__BUF_4
X275 _109_/I _125_/RN VDD VDD VSS VSS GF180MCU_FD_SC_MCU7T5V0__CLKINV_1
X276 VDD VDD VSS VSS GF180MCU_FD_SC_MCU7T5V0__FILL_1
X277 VDD VDD VSS VSS GF180MCU_FD_SC_MCU7T5V0__FILL_2
X278 VDD VSS GF180MCU_FD_SC_MCU7T5V0__FILLTIE
X279 wire51/I _086_/S VDD VDD VSS VSS GF180MCU_FD_SC_MCU7T5V0__DLYB_1
X280 _157_/I _062_/I VDD VDD VSS VSS GF180MCU_FD_SC_MCU7T5V0__BUF_4
X281 _159_/I _159_/Z VDD VDD VSS VSS GF180MCU_FD_SC_MCU7T5V0__BUF_4
X282 VDD VDD VSS VSS GF180MCU_FD_SC_MCU7T5V0__FILL_2
X283 VDD VSS GF180MCU_FD_SC_MCU7T5V0__FILLTIE
X284 _175_/I _175_/Z VDD VDD VSS VSS GF180MCU_FD_SC_MCU7T5V0__BUF_4
X285 VDD VDD VSS VSS GF180MCU_FD_SC_MCU7T5V0__FILL_1
X286 wire52/I _082_/S VDD VDD VSS VSS GF180MCU_FD_SC_MCU7T5V0__DLYB_1
X287 _158_/I _158_/Z VDD VDD VSS VSS GF180MCU_FD_SC_MCU7T5V0__BUF_4
X288 _089_/A1 _091_/A1 wire50/I VDD VDD VSS VSS GF180MCU_FD_SC_MCU7T5V0__NOR2_1
X289 VDD VSS GF180MCU_FD_SC_MCU7T5V0__ENDCAP
X290 VDD VSS GF180MCU_FD_SC_MCU7T5V0__ENDCAP
X291 VDD VSS GF180MCU_FD_SC_MCU7T5V0__FILLTIE
X292 VDD VDD VSS VSS GF180MCU_FD_SC_MCU7T5V0__FILL_2
X293 _174_/I _174_/Z VDD VDD VSS VSS GF180MCU_FD_SC_MCU7T5V0__BUF_1
X294 VDD VDD VSS VSS GF180MCU_FD_SC_MCU7T5V0__FILL_1
X295 wire53/I _078_/S VDD VDD VSS VSS GF180MCU_FD_SC_MCU7T5V0__DLYB_1
X296 _157_/I _157_/Z VDD VDD VSS VSS GF180MCU_FD_SC_MCU7T5V0__BUF_4
X297 _088_/I0 _088_/I1 _088_/S _125_/D VDD VDD VSS VSS GF180MCU_FD_SC_MCU7T5V0__MUX2_2
X298 VDD VDD VSS VSS GF180MCU_FD_SC_MCU7T5V0__FILL_1
X299 VDD VDD VSS VSS GF180MCU_FD_SC_MCU7T5V0__FILLCAP_8
X300 VDD VSS GF180MCU_FD_SC_MCU7T5V0__FILLTIE
X301 VDD VSS GF180MCU_FD_SC_MCU7T5V0__ENDCAP
X302 _173_/I _173_/Z VDD VDD VSS VSS GF180MCU_FD_SC_MCU7T5V0__BUF_1
X303 VDD VDD VSS VSS GF180MCU_FD_SC_MCU7T5V0__FILLCAP_32
X304 VDD VDD VSS VSS GF180MCU_FD_SC_MCU7T5V0__FILL_1
X305 wire54/I _074_/S VDD VDD VSS VSS GF180MCU_FD_SC_MCU7T5V0__DLYC_1
X306 VDD VDD VSS VSS GF180MCU_FD_SC_MCU7T5V0__FILL_1
X307 _156_/I _156_/Z VDD VDD VSS VSS GF180MCU_FD_SC_MCU7T5V0__BUF_4
X308 _087_/A1 _141_/Q _088_/S VDD VDD VSS VSS GF180MCU_FD_SC_MCU7T5V0__NAND2_1
X309 VDD VDD VSS VSS GF180MCU_FD_SC_MCU7T5V0__FILLCAP_8
X310 VDD VDD VSS VSS GF180MCU_FD_SC_MCU7T5V0__FILL_1
X311 _169_/I _139_/RN _143_/CLK _168_/I VDD VDD VSS VSS GF180MCU_FD_SC_MCU7T5V0__DFFRNQ_2
X312 VDD VDD VSS VSS GF180MCU_FD_SC_MCU7T5V0__FILLCAP_16
X313 VDD VSS GF180MCU_FD_SC_MCU7T5V0__FILLTIE
X314 wire55/I _142_/D VDD VDD VSS VSS GF180MCU_FD_SC_MCU7T5V0__CLKBUF_1
X315 _161_/I wire77/Z VDD VDD VSS VSS GF180MCU_FD_SC_MCU7T5V0__BUF_4
X316 _155_/I _155_/Z VDD VDD VSS VSS GF180MCU_FD_SC_MCU7T5V0__BUF_4
X317 _086_/I0 _086_/I1 _086_/S _126_/D VDD VDD VSS VSS GF180MCU_FD_SC_MCU7T5V0__MUX2_2
X318 VDD VDD VSS VSS GF180MCU_FD_SC_MCU7T5V0__FILL_2
X319 _168_/I _138_/RN _143_/CLK _167_/I VDD VDD VSS VSS GF180MCU_FD_SC_MCU7T5V0__DFFRNQ_2
X320 _069_/I _079_/A1 VDD VDD VSS VSS GF180MCU_FD_SC_MCU7T5V0__CLKINV_1
X321 VDD VDD VSS VSS GF180MCU_FD_SC_MCU7T5V0__FILL_1
X322 VDD VSS GF180MCU_FD_SC_MCU7T5V0__ENDCAP
X323 VDD VDD VSS VSS GF180MCU_FD_SC_MCU7T5V0__FILL_2
X324 _171_/I _171_/Z VDD VDD VSS VSS GF180MCU_FD_SC_MCU7T5V0__BUF_4
X325 VDD VDD VSS VSS GF180MCU_FD_SC_MCU7T5V0__FILL_1
X326 VDD VDD VSS VSS GF180MCU_FD_SC_MCU7T5V0__FILLCAP_8
X327 _154_/I _154_/Z VDD VDD VSS VSS GF180MCU_FD_SC_MCU7T5V0__BUF_4
X328 _085_/A1 _087_/A1 wire51/I VDD VDD VSS VSS GF180MCU_FD_SC_MCU7T5V0__NOR2_1
X329 _167_/I _137_/RN _143_/CLK _166_/I VDD VDD VSS VSS GF180MCU_FD_SC_MCU7T5V0__DFFRNQ_2
X330 _133_/D _075_/A1 VDD VDD VSS VSS GF180MCU_FD_SC_MCU7T5V0__CLKINV_1
X331 VDD VSS GF180MCU_FD_SC_MCU7T5V0__ENDCAP
X332 VDD VDD VSS VSS GF180MCU_FD_SC_MCU7T5V0__FILLCAP_4
X333 _170_/I _170_/Z VDD VDD VSS VSS GF180MCU_FD_SC_MCU7T5V0__BUF_4
X334 VDD VSS GF180MCU_FD_SC_MCU7T5V0__ENDCAP
X335 _173_/I _164_/I VDD VDD VSS VSS GF180MCU_FD_SC_MCU7T5V0__BUF_4
X336 wire82/Z _158_/I _084_/S _127_/D VDD VDD VSS VSS GF180MCU_FD_SC_MCU7T5V0__MUX2_2
X337 VDD VDD VSS VSS GF180MCU_FD_SC_MCU7T5V0__FILLCAP_4
X338 VDD VDD VSS VSS GF180MCU_FD_SC_MCU7T5V0__FILL_1
X339 VDD VDD VSS VSS GF180MCU_FD_SC_MCU7T5V0__FILL_2
X340 _175_/I _136_/RN _142_/CLK _174_/I VDD VDD VSS VSS GF180MCU_FD_SC_MCU7T5V0__DFFRNQ_2
X341 VDD VDD VSS VSS GF180MCU_FD_SC_MCU7T5V0__FILL_1
X342 VDD VDD VSS VSS GF180MCU_FD_SC_MCU7T5V0__FILLCAP_4
X343 VDD VDD VSS VSS GF180MCU_FD_SC_MCU7T5V0__FILLCAP_4
X344 _162_/I _067_/ZN VDD VDD VSS VSS GF180MCU_FD_SC_MCU7T5V0__CLKINV_1
X345 _121_/I _119_/A2 _119_/Z VDD VDD VSS VSS GF180MCU_FD_SC_MCU7T5V0__OR2_1
X346 _163_/I _133_/D VDD VDD VSS VSS GF180MCU_FD_SC_MCU7T5V0__BUF_4
X347 _083_/A1 _085_/A1 _084_/S VDD VDD VSS VSS GF180MCU_FD_SC_MCU7T5V0__NAND2_1
X348 _174_/I _135_/RN _142_/CLK _173_/I VDD VDD VSS VSS GF180MCU_FD_SC_MCU7T5V0__DFFRNQ_2
X349 _161_/I _066_/ZN VDD VDD VSS VSS GF180MCU_FD_SC_MCU7T5V0__CLKINV_1
X350 VDD VDD VSS VSS GF180MCU_FD_SC_MCU7T5V0__FILL_1
X351 VDD VDD VSS VSS GF180MCU_FD_SC_MCU7T5V0__FILL_2
X352 _122_/I _143_/Q _118_/Z VDD VDD VSS VSS GF180MCU_FD_SC_MCU7T5V0__OR2_1
X353 _058_/ZN B[0] VDD VDD VSS VSS GF180MCU_FD_SC_MCU7T5V0__BUF_1
X354 VDD VDD VSS VSS GF180MCU_FD_SC_MCU7T5V0__FILLCAP_4
X355 _157_/I _082_/I1 _082_/S _128_/D VDD VDD VSS VSS GF180MCU_FD_SC_MCU7T5V0__MUX2_2
X356 VDD VSS GF180MCU_FD_SC_MCU7T5V0__FILLTIE
X357 VDD VDD VSS VSS GF180MCU_FD_SC_MCU7T5V0__FILL_1
X358 VDD VDD VSS VSS GF180MCU_FD_SC_MCU7T5V0__FILL_1
X359 VDD VSS GF180MCU_FD_SC_MCU7T5V0__FILLTIE
X360 _164_/I _134_/RN _143_/CLK _163_/I VDD VDD VSS VSS GF180MCU_FD_SC_MCU7T5V0__DFFRNQ_2
X361 _160_/I _065_/ZN VDD VDD VSS VSS GF180MCU_FD_SC_MCU7T5V0__CLKINV_1
X362 _122_/I _143_/Q _117_/Z VDD VDD VSS VSS GF180MCU_FD_SC_MCU7T5V0__OR2_1
X363 VDD VDD VSS VSS GF180MCU_FD_SC_MCU7T5V0__FILL_1
X364 _059_/ZN B[1] VDD VDD VSS VSS GF180MCU_FD_SC_MCU7T5V0__BUF_1
X365 VDD VDD VSS VSS GF180MCU_FD_SC_MCU7T5V0__FILL_2
X366 VDD VDD VSS VSS GF180MCU_FD_SC_MCU7T5V0__FILLCAP_4
X367 _175_/I _083_/A1 wire52/I VDD VDD VSS VSS GF180MCU_FD_SC_MCU7T5V0__NOR2_1
X368 VDD VSS GF180MCU_FD_SC_MCU7T5V0__FILLTIE
X369 VDD VDD VSS VSS GF180MCU_FD_SC_MCU7T5V0__FILLCAP_4
X370 VDD VSS GF180MCU_FD_SC_MCU7T5V0__FILLTIE
X371 VDD VDD VSS VSS GF180MCU_FD_SC_MCU7T5V0__FILLCAP_8
X372 VDD VDD VSS VSS GF180MCU_FD_SC_MCU7T5V0__FILLCAP_4
X373 _133_/D _133_/RN _142_/CLK _133_/Q VDD VDD VSS VSS GF180MCU_FD_SC_MCU7T5V0__DFFRNQ_1
X374 _159_/I _064_/ZN VDD VDD VSS VSS GF180MCU_FD_SC_MCU7T5V0__CLKINV_1
X375 VDD VDD VSS VSS GF180MCU_FD_SC_MCU7T5V0__FILL_1
X376 VDD VDD VSS VSS GF180MCU_FD_SC_MCU7T5V0__FILLCAP_8
X377 VDD VSS GF180MCU_FD_SC_MCU7T5V0__ENDCAP
X378 _121_/I _119_/A2 _116_/Z VDD VDD VSS VSS GF180MCU_FD_SC_MCU7T5V0__OR2_1
X379 VDD VSS GF180MCU_FD_SC_MCU7T5V0__ENDCAP
X380 VDD VDD VSS VSS GF180MCU_FD_SC_MCU7T5V0__FILLCAP_4
X381 _133_/D SW1p[0] VDD VDD VSS VSS GF180MCU_FD_SC_MCU7T5V0__BUF_1
X382 _060_/ZN B[2] VDD VDD VSS VSS GF180MCU_FD_SC_MCU7T5V0__BUF_1
X383 clkbuf_0_CLK/Z _143_/CLK VDD VDD VSS VSS GF180MCU_FD_SC_MCU7T5V0__CLKBUF_16
X384 VDD VDD VSS VSS GF180MCU_FD_SC_MCU7T5V0__FILL_1
X385 _086_/I1 _061_/I _080_/S _129_/D VDD VDD VSS VSS GF180MCU_FD_SC_MCU7T5V0__MUX2_2
X386 VDD VSS GF180MCU_FD_SC_MCU7T5V0__FILLTIE
X387 VDD VDD VSS VSS GF180MCU_FD_SC_MCU7T5V0__FILL_1
X388 VDD VSS GF180MCU_FD_SC_MCU7T5V0__FILLTIE
X389 _132_/D _132_/RN _120_/Z _143_/CLK _132_/Q VDD VDD VSS VSS GF180MCU_FD_SC_MCU7T5V0__DFFRSNQ_1
X390 _063_/I _063_/ZN VDD VDD VSS VSS GF180MCU_FD_SC_MCU7T5V0__CLKINV_1
X391 VDD VDD VSS VSS GF180MCU_FD_SC_MCU7T5V0__FILL_1
X392 VDD VDD VSS VSS GF180MCU_FD_SC_MCU7T5V0__FILLCAP_4
X393 VDD VDD VSS VSS GF180MCU_FD_SC_MCU7T5V0__FILL_2
X394 _121_/I _119_/A2 _115_/Z VDD VDD VSS VSS GF180MCU_FD_SC_MCU7T5V0__OR2_1
X395 VDD VDD VSS VSS GF180MCU_FD_SC_MCU7T5V0__FILLCAP_4
X396 _162_/Z SW0p[8] VDD VDD VSS VSS GF180MCU_FD_SC_MCU7T5V0__BUF_4
X397 _173_/Z SW1p[1] VDD VDD VSS VSS GF180MCU_FD_SC_MCU7T5V0__BUF_1
X398 _061_/ZN B[3] VDD VDD VSS VSS GF180MCU_FD_SC_MCU7T5V0__BUF_1
.ends sar_logic
