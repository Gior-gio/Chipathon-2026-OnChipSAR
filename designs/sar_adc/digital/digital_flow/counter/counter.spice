* ==========================================
* LVS READY - MÓDULO: COUNTER
* ==========================================

.SUBCKT gf180mcu_fd_sc_mcu7t5v0__and3_1 A1 A2 A3 Z VDD VNW VPW VSS
X_i_2 net_0 A1 Z_neg VPW nfet_05v0 W=3.8e-07 L=6e-07
X_i_3 net_1 A2 net_0 VPW nfet_05v0 W=3.8e-07 L=6e-07
X_i_4 VSS A3 net_1 VPW nfet_05v0 W=3.8e-07 L=6e-07
X_i_0 Z Z_neg VSS VPW nfet_05v0 W=7.75e-07 L=6e-07
X_i_5 VDD A1 Z_neg VNW pfet_05v0 W=5.35e-07 L=5e-07
X_i_6 Z_neg A2 VDD VNW pfet_05v0 W=5.35e-07 L=5e-07
X_i_7 VDD A3 Z_neg VNW pfet_05v0 W=5.35e-07 L=5e-07
X_i_1 Z Z_neg VDD VNW pfet_05v0 W=1.215e-06 L=5e-07
.ENDS
.SUBCKT gf180mcu_fd_sc_mcu7t5v0__antenna I VDD VNW VPW VSS
D0 VPW I diode_nd2ps_06v0 AREA=0.2052p PJ=1.86u M=1
D1 I VNW diode_pd2nw_06v0 AREA=0.2052p PJ=1.86u M=1
.ENDS
.SUBCKT gf180mcu_fd_sc_mcu7t5v0__aoi21_1 A1 A2 B ZN VDD VNW VPW VSS
X_i_1 net_0 A2 VSS VPW nfet_05v0 W=8.2e-07 L=6e-07
X_i_0 ZN A1 net_0 VPW nfet_05v0 W=8.2e-07 L=6e-07
X_i_2 VSS B ZN VPW nfet_05v0 W=5.1e-07 L=6e-07
X_i_4 ZN A2 net_1 VNW pfet_05v0 W=1.215e-06 L=5e-07
X_i_3 net_1 A1 ZN VNW pfet_05v0 W=1.215e-06 L=5e-07
X_i_5 VDD B net_1 VNW pfet_05v0 W=1.215e-06 L=5e-07
.ENDS
.SUBCKT gf180mcu_fd_sc_mcu7t5v0__clkbuf_16 I Z VDD VNW VPW VSS
X_i_2_0 Z_neg I VSS VPW nfet_05v0 W=4.05e-07 L=6e-07
X_i_2_1 VSS I Z_neg VPW nfet_05v0 W=4.05e-07 L=6e-07
X_i_2_2 Z_neg I VSS VPW nfet_05v0 W=4.05e-07 L=6e-07
X_i_2_3 VSS I Z_neg VPW nfet_05v0 W=4.05e-07 L=6e-07
X_i_2_4 Z_neg I VSS VPW nfet_05v0 W=4.05e-07 L=6e-07
X_i_2_5 VSS I Z_neg VPW nfet_05v0 W=4.05e-07 L=6e-07
X_i_0_0 Z Z_neg VSS VPW nfet_05v0 W=4.85e-07 L=6e-07
X_i_0_1 VSS Z_neg Z VPW nfet_05v0 W=4.85e-07 L=6e-07
X_i_0_2 Z Z_neg VSS VPW nfet_05v0 W=4.85e-07 L=6e-07
X_i_0_3 VSS Z_neg Z VPW nfet_05v0 W=4.85e-07 L=6e-07
X_i_0_4 Z Z_neg VSS VPW nfet_05v0 W=4.85e-07 L=6e-07
X_i_0_5 VSS Z_neg Z VPW nfet_05v0 W=4.85e-07 L=6e-07
X_i_0_6 Z Z_neg VSS VPW nfet_05v0 W=4.85e-07 L=6e-07
X_i_0_7 VSS Z_neg Z VPW nfet_05v0 W=4.85e-07 L=6e-07
X_i_0_8 Z Z_neg VSS VPW nfet_05v0 W=4.85e-07 L=6e-07
X_i_0_9 VSS Z_neg Z VPW nfet_05v0 W=4.85e-07 L=6e-07
X_i_0_10 Z Z_neg VSS VPW nfet_05v0 W=4.85e-07 L=6e-07
X_i_0_11 VSS Z_neg Z VPW nfet_05v0 W=4.85e-07 L=6e-07
X_i_0_12 Z Z_neg VSS VPW nfet_05v0 W=4.85e-07 L=6e-07
X_i_0_13 VSS Z_neg Z VPW nfet_05v0 W=4.85e-07 L=6e-07
X_i_0_14 Z Z_neg VSS VPW nfet_05v0 W=4.85e-07 L=6e-07
X_i_0_15 VSS Z_neg Z VPW nfet_05v0 W=4.85e-07 L=6e-07
X_i_3_0 Z_neg I VDD VNW pfet_05v0 W=0.82e-06 L=5e-07
X_i_3_1 VDD I Z_neg VNW pfet_05v0 W=0.82e-06 L=5e-07
X_i_3_2 Z_neg I VDD VNW pfet_05v0 W=0.82e-06 L=5e-07
X_i_3_3 VDD I Z_neg VNW pfet_05v0 W=0.82e-06 L=5e-07
X_i_3_4 Z_neg I VDD VNW pfet_05v0 W=0.82e-06 L=5e-07
X_i_3_5 VDD I Z_neg VNW pfet_05v0 W=0.82e-06 L=5e-07
X_i_3_6 Z_neg I VDD VNW pfet_05v0 W=0.82e-06 L=5e-07
X_i_3_7 VDD I Z_neg VNW pfet_05v0 W=0.82e-06 L=5e-07
X_i_1_0 Z Z_neg VDD VNW pfet_05v0 W=1.22e-06 L=5e-07
X_i_1_1 VDD Z_neg Z VNW pfet_05v0 W=1.22e-06 L=5e-07
X_i_1_2 Z Z_neg VDD VNW pfet_05v0 W=1.22e-06 L=5e-07
X_i_1_3 VDD Z_neg Z VNW pfet_05v0 W=1.22e-06 L=5e-07
X_i_1_4 Z Z_neg VDD VNW pfet_05v0 W=1.22e-06 L=5e-07
X_i_1_5 VDD Z_neg Z VNW pfet_05v0 W=1.22e-06 L=5e-07
X_i_1_6 Z Z_neg VDD VNW pfet_05v0 W=1.22e-06 L=5e-07
X_i_1_7 VDD Z_neg Z VNW pfet_05v0 W=1.22e-06 L=5e-07
X_i_1_8 Z Z_neg VDD VNW pfet_05v0 W=1.22e-06 L=5e-07
X_i_1_9 VDD Z_neg Z VNW pfet_05v0 W=1.22e-06 L=5e-07
X_i_1_10 Z Z_neg VDD VNW pfet_05v0 W=1.22e-06 L=5e-07
X_i_1_11 VDD Z_neg Z VNW pfet_05v0 W=1.22e-06 L=5e-07
X_i_1_12 Z Z_neg VDD VNW pfet_05v0 W=1.22e-06 L=5e-07
X_i_1_13 VDD Z_neg Z VNW pfet_05v0 W=1.22e-06 L=5e-07
X_i_1_14 Z Z_neg VDD VNW pfet_05v0 W=1.22e-06 L=5e-07
X_i_1_15 VDD Z_neg Z VNW pfet_05v0 W=1.22e-06 L=5e-07
.ENDS
.SUBCKT gf180mcu_fd_sc_mcu7t5v0__dffq_1 D CLK Q VDD VNW VPW VSS
X_tn3 VSS CLK ncki VPW nfet_05v0 W=4.05e-07 L=6e-07
X_tn4 cki ncki VSS VPW nfet_05v0 W=4.05e-07 L=6e-07
X_tn5 net5 ncki VSS VPW nfet_05v0 W=3.6e-07 L=6e-07
X_tn8 net4 D net5 VPW nfet_05v0 W=3.6e-07 L=6e-07
X_tn6 net6 cki net4 VPW nfet_05v0 W=3.6e-07 L=6e-07
X_tn7 VSS net0 net6 VPW nfet_05v0 W=3.6e-07 L=6e-07
X_tn0 net0 net4 VSS VPW nfet_05v0 W=3.6e-07 L=6e-07
X_tn9 net2 cki net0 VPW nfet_05v0 W=3.6e-07 L=6e-07
X_tn11 net1 ncki net2 VPW nfet_05v0 W=3.6e-07 L=6e-07
X_tn12 VSS net3 net1 VPW nfet_05v0 W=3.6e-07 L=6e-07
X_tn10 net3 net2 VSS VPW nfet_05v0 W=4e-07 L=6e-07
X_tn1 Q net3 VSS VPW nfet_05v0 W=8.2e-07 L=6e-07
X_tp3 VDD CLK ncki VNW pfet_05v0 W=8.65e-07 L=5e-07
X_tp4 cki ncki VDD VNW pfet_05v0 W=8.65e-07 L=5e-07
X_tp12 net7 cki VDD VNW pfet_05v0 W=3.6e-07 L=5e-07
X_tp11 net4 D net7 VNW pfet_05v0 W=3.6e-07 L=5e-07
X_tp6 net8 ncki net4 VNW pfet_05v0 W=3.6e-07 L=5e-07
X_tp5 VDD net0 net8 VNW pfet_05v0 W=3.6e-07 L=5e-07
X_tp0 net0 net4 VDD VNW pfet_05v0 W=3.6e-07 L=5e-07
X_tp7 net2 ncki net0 VNW pfet_05v0 W=3.6e-07 L=5e-07
X_tp9 net1x cki net2 VNW pfet_05v0 W=3.6e-07 L=5e-07
X_tp10 VDD net3 net1x VNW pfet_05v0 W=3.6e-07 L=5e-07
X_tp8 net3 net2 VDD VNW pfet_05v0 W=8e-07 L=5e-07
X_tp1 Q net3 VDD VNW pfet_05v0 W=1.22e-06 L=5e-07
.ENDS
.SUBCKT gf180mcu_fd_sc_mcu7t5v0__dlyb_1 I Z VDD VNW VPW VSS
X_i_2_0 Z_neg I VSS VPW nfet_05v0 W=3.6e-07 L=6e-07
X_i_2 net_2 Z_neg net_1 VPW nfet_05v0 W=3.6e-07 L=6e-07
X_i_3 net_1 Z_neg VSS VPW nfet_05v0 W=3.6e-07 L=6e-07
X_i_2_21 net_3 net_2 net_6 VPW nfet_05v0 W=3.65e-07 L=0.600000U
X_i_3_6 net_6 net_2 VSS VPW nfet_05v0 W=3.65e-07 L=6e-07
X_i_2_0_18 Z net_3 VSS VPW nfet_05v0 W=8.2e-07 L=6e-07
X_i_3_0 Z_neg I VDD VNW pfet_05v0 W=3.6e-07 L=5e-07
X_i_0 net_0 Z_neg VDD VNW pfet_05v0 W=3.6e-07 L=5e-07
X_i_1 net_2 Z_neg net_0 VNW pfet_05v0 W=3.6e-07 L=5e-07
X_i_0_29 net_5 net_2 VDD VNW pfet_05v0 W=3.6e-07 L=5e-07
X_i_1_39 net_3 net_2 net_5 VNW pfet_05v0 W=3.6e-07 L=5e-07
X_i_3_0_0 Z net_3 VDD VNW pfet_05v0 W=1.22e-06 L=5e-07
.ENDS
.SUBCKT gf180mcu_fd_sc_mcu7t5v0__endcap VDD VSS
.ENDS
.SUBCKT gf180mcu_fd_sc_mcu7t5v0__fill_1 VDD VNW VPW VSS
.ENDS
.SUBCKT gf180mcu_fd_sc_mcu7t5v0__fill_2 VDD VNW VPW VSS
.ENDS
.SUBCKT gf180mcu_fd_sc_mcu7t5v0__fillcap_4 VDD VNW VPW VSS
X_i_17 net_1 net_0 VSS VPW nfet_05v0 W=8.2e-07 L=1e-06
X_i_19 VDD net_1 net_0 VNW pfet_05v0 W=1.22e-06 L=1e-06
.ENDS
.SUBCKT gf180mcu_fd_sc_mcu7t5v0__fillcap_8 VDD VNW VPW VSS
X_i_17 net_3 net_2 VSS VPW nfet_05v0 W=8.2e-07 L=1e-06
X_i_17_23 net_4 net_5 VSS VPW nfet_05v0 W=8.2e-07 L=1e-06
X_i_19 VDD net_3 net_2 VNW pfet_05v0 W=1.22e-06 L=1e-06
X_i_19_7 VDD net_4 net_5 VNW pfet_05v0 W=1.22e-06 L=1e-06
.ENDS
.SUBCKT gf180mcu_fd_sc_mcu7t5v0__fillcap_16 VDD VNW VPW VSS
X_i_17 net_3 net_2 VSS VPW nfet_05v0 W=8.2e-07 L=1e-06
X_i_17_23 net_4 net_5 VSS VPW nfet_05v0 W=8.2e-07 L=1e-06
X_i_17_24 net_7 net_9 VSS VPW nfet_05v0 W=8.2e-07 L=1e-06
X_i_17_23_55 net_6 net_8 VSS VPW nfet_05v0 W=8.2e-07 L=1e-06
X_i_19 VDD net_3 net_2 VNW pfet_05v0 W=1.22e-06 L=1e-06
X_i_19_7 VDD net_4 net_5 VNW pfet_05v0 W=1.22e-06 L=1e-06
X_i_19_33 VDD net_7 net_9 VNW pfet_05v0 W=1.22e-06 L=1e-06
X_i_19_7_23 VDD net_6 net_8 VNW pfet_05v0 W=1.22e-06 L=1e-06
.ENDS
.SUBCKT gf180mcu_fd_sc_mcu7t5v0__fillcap_32 VDD VNW VPW VSS
X_i_17 net_3 net_2 VSS VPW nfet_05v0 W=8.2e-07 L=1e-06
X_i_17_23 net_4 net_5 VSS VPW nfet_05v0 W=8.2e-07 L=1e-06
X_i_17_24 net_7 net_9 VSS VPW nfet_05v0 W=8.2e-07 L=1e-06
X_i_17_23_55 net_6 net_8 VSS VPW nfet_05v0 W=8.2e-07 L=1e-06
X_i_17_27 net_17 net_14 VSS VPW nfet_05v0 W=8.2e-07 L=1e-06
X_i_17_23_63 net_16 net_15 VSS VPW nfet_05v0 W=8.2e-07 L=1e-06
X_i_17_24_22 net_13 net_11 VSS VPW nfet_05v0 W=8.2e-07 L=1e-06
X_i_17_23_55_93 net_12 net_10 VSS VPW nfet_05v0 W=8.2e-07 L=1e-06
X_i_19 VDD net_3 net_2 VNW pfet_05v0 W=1.22e-06 L=1e-06
X_i_19_7 VDD net_4 net_5 VNW pfet_05v0 W=1.22e-06 L=1e-06
X_i_19_33 VDD net_7 net_9 VNW pfet_05v0 W=1.22e-06 L=1e-06
X_i_19_7_23 VDD net_6 net_8 VNW pfet_05v0 W=1.22e-06 L=1e-06
X_i_19_94 VDD net_17 net_14 VNW pfet_05v0 W=1.22e-06 L=1e-06
X_i_19_7_87 VDD net_16 net_15 VNW pfet_05v0 W=1.22e-06 L=1e-06
X_i_19_33_95 VDD net_13 net_11 VNW pfet_05v0 W=1.22e-06 L=1e-06
X_i_19_7_23_23 VDD net_12 net_10 VNW pfet_05v0 W=1.22e-06 L=1e-06
.ENDS
.SUBCKT gf180mcu_fd_sc_mcu7t5v0__filltie VDD VSS
.ENDS
.SUBCKT gf180mcu_fd_sc_mcu7t5v0__nor2_1 A1 A2 ZN VDD VNW VPW VSS
X_i_1 ZN A2 VSS VPW nfet_05v0 W=5.65e-07 L=6e-07
X_i_0 VSS A1 ZN VPW nfet_05v0 W=5.65e-07 L=6e-07
X_i_3 net_0 A2 VDD VNW pfet_05v0 W=1.22e-06 L=5e-07
X_i_2 ZN A1 net_0 VNW pfet_05v0 W=1.22e-06 L=5e-07
.ENDS
.SUBCKT gf180mcu_fd_sc_mcu7t5v0__nor3_1 A1 A2 A3 ZN VDD VNW VPW VSS
X_i_2 ZN A3 VSS VPW nfet_05v0 W=4.65e-07 L=6e-07
X_i_1 VSS A2 ZN VPW nfet_05v0 W=4.65e-07 L=6e-07
X_i_0 ZN A1 VSS VPW nfet_05v0 W=4.65e-07 L=6e-07
X_i_5 net_1 A3 VDD VNW pfet_05v0 W=1.22e-06 L=5e-07
X_i_4 net_0 A2 net_1 VNW pfet_05v0 W=1.22e-06 L=5e-07
X_i_3 ZN A1 net_0 VNW pfet_05v0 W=1.22e-06 L=5e-07
.ENDS
.SUBCKT gf180mcu_fd_sc_mcu7t5v0__xnor2_1 A1 A2 ZN VDD VNW VPW VSS
X_i_6 net_2 A2 I VPW nfet_05v0 W=3.6e-07 L=6e-07
X_i_7 VSS A1 net_2 VPW nfet_05v0 W=3.6e-07 L=6e-07
X_i_2 net_0 I VSS VPW nfet_05v0 W=8.2e-07 L=6e-07
X_i_0 ZN A1 net_0 VPW nfet_05v0 W=8.2e-07 L=6e-07
X_i_1 net_0 A2 ZN VPW nfet_05v0 W=8.2e-07 L=6e-07
X_i_8 I A2 VDD VNW pfet_05v0 W=5.6e-07 L=5e-07
X_i_9 VDD A1 I VNW pfet_05v0 W=5.6e-07 L=5e-07
X_i_5 ZN I VDD VNW pfet_05v0 W=1.095e-06 L=5e-07
X_i_3 net_1 A1 ZN VNW pfet_05v0 W=1.095e-06 L=5e-07
X_i_4 VDD A2 net_1 VNW pfet_05v0 W=1.095e-06 L=5e-07
.ENDS

* --- DISEÑO DIGITAL ---
.subckt counter VDD VSS clk q[0] q[1] q[2] q[3] rst

X1 VDD VDD VSS VSS GF180MCU_FD_SC_MCU7T5V0__FILLCAP_4
X2 VDD VDD VSS VSS GF180MCU_FD_SC_MCU7T5V0__FILL_1
X3 VDD VDD VSS VSS GF180MCU_FD_SC_MCU7T5V0__FILLCAP_16
X4 VDD VSS GF180MCU_FD_SC_MCU7T5V0__ENDCAP
X5 VDD VDD VSS VSS GF180MCU_FD_SC_MCU7T5V0__FILLCAP_4
X6 VDD VSS GF180MCU_FD_SC_MCU7T5V0__FILLTIE
X7 VDD VDD VSS VSS GF180MCU_FD_SC_MCU7T5V0__FILL_2
X8 VDD VDD VSS VSS GF180MCU_FD_SC_MCU7T5V0__FILL_1
X9 VDD VDD VSS VSS GF180MCU_FD_SC_MCU7T5V0__FILLCAP_8
X10 VDD VDD VSS VSS GF180MCU_FD_SC_MCU7T5V0__FILL_2
X11 VDD VDD VSS VSS GF180MCU_FD_SC_MCU7T5V0__FILLCAP_32
X12 VDD VDD VSS VSS GF180MCU_FD_SC_MCU7T5V0__FILL_1
X13 rst VDD VDD VSS VSS GF180MCU_FD_SC_MCU7T5V0__ANTENNA
X14 VDD VDD VSS VSS GF180MCU_FD_SC_MCU7T5V0__FILLCAP_8
X15 VDD VDD VSS VSS GF180MCU_FD_SC_MCU7T5V0__FILLCAP_32
X16 VDD VDD VSS VSS GF180MCU_FD_SC_MCU7T5V0__FILLCAP_8
X17 VDD VSS GF180MCU_FD_SC_MCU7T5V0__ENDCAP
X18 _16_/Q _17_/Q _18_/Q _09_/Z VDD VDD VSS VSS GF180MCU_FD_SC_MCU7T5V0__AND3_1
X19 VDD VSS GF180MCU_FD_SC_MCU7T5V0__ENDCAP
X20 _16_/Q _17_/Q _18_/Q _10_/A2 VDD VDD VSS VSS GF180MCU_FD_SC_MCU7T5V0__AOI21_1
X21 VDD VDD VSS VSS GF180MCU_FD_SC_MCU7T5V0__FILLCAP_4
X22 clk clkbuf_0_clk/Z VDD VDD VSS VSS GF180MCU_FD_SC_MCU7T5V0__CLKBUF_16
X23 VDD VDD VSS VSS GF180MCU_FD_SC_MCU7T5V0__FILLCAP_4
X24 VDD VDD VSS VSS GF180MCU_FD_SC_MCU7T5V0__FILLCAP_4
X25 VDD VSS GF180MCU_FD_SC_MCU7T5V0__ENDCAP
X26 VDD VDD VSS VSS GF180MCU_FD_SC_MCU7T5V0__FILL_1
X27 VDD VDD VSS VSS GF180MCU_FD_SC_MCU7T5V0__FILLCAP_16
X28 VDD VSS GF180MCU_FD_SC_MCU7T5V0__ENDCAP
X29 VDD VSS GF180MCU_FD_SC_MCU7T5V0__ENDCAP
X30 VDD VDD VSS VSS GF180MCU_FD_SC_MCU7T5V0__FILLCAP_8
X31 VDD VSS GF180MCU_FD_SC_MCU7T5V0__FILLTIE
X32 VDD VDD VSS VSS GF180MCU_FD_SC_MCU7T5V0__FILL_1
X33 VDD VDD VSS VSS GF180MCU_FD_SC_MCU7T5V0__FILL_1
X34 VDD VDD VSS VSS GF180MCU_FD_SC_MCU7T5V0__FILL_2
X35 VDD VDD VSS VSS GF180MCU_FD_SC_MCU7T5V0__FILL_2
X36 VDD VDD VSS VSS GF180MCU_FD_SC_MCU7T5V0__FILL_2
X37 rst _15_/A1 VDD VDD VSS VSS GF180MCU_FD_SC_MCU7T5V0__DLYB_1
X38 clk VDD VDD VSS VSS GF180MCU_FD_SC_MCU7T5V0__ANTENNA
X39 VDD VDD VSS VSS GF180MCU_FD_SC_MCU7T5V0__FILLCAP_32
X40 VDD VDD VSS VSS GF180MCU_FD_SC_MCU7T5V0__FILL_1
X41 VDD VSS GF180MCU_FD_SC_MCU7T5V0__ENDCAP
X42 VDD VSS GF180MCU_FD_SC_MCU7T5V0__FILLTIE
X43 VDD VDD VSS VSS GF180MCU_FD_SC_MCU7T5V0__FILL_1
X44 VDD VSS GF180MCU_FD_SC_MCU7T5V0__ENDCAP
X45 VDD VSS GF180MCU_FD_SC_MCU7T5V0__FILLTIE
X46 VDD VSS GF180MCU_FD_SC_MCU7T5V0__FILLTIE
X47 VDD VDD VSS VSS GF180MCU_FD_SC_MCU7T5V0__FILLCAP_4
X48 VDD VSS GF180MCU_FD_SC_MCU7T5V0__FILLTIE
X49 VDD VDD VSS VSS GF180MCU_FD_SC_MCU7T5V0__FILL_1
X50 VDD VSS GF180MCU_FD_SC_MCU7T5V0__FILLTIE
X51 VDD VSS GF180MCU_FD_SC_MCU7T5V0__ENDCAP
X52 VDD VDD VSS VSS GF180MCU_FD_SC_MCU7T5V0__FILLCAP_16
X53 VDD VSS GF180MCU_FD_SC_MCU7T5V0__ENDCAP
X54 VDD VDD VSS VSS GF180MCU_FD_SC_MCU7T5V0__FILLCAP_8
X55 VDD VDD VSS VSS GF180MCU_FD_SC_MCU7T5V0__FILL_2
X56 VDD VSS GF180MCU_FD_SC_MCU7T5V0__ENDCAP
X57 VDD VDD VSS VSS GF180MCU_FD_SC_MCU7T5V0__FILL_2
X58 VDD VDD VSS VSS GF180MCU_FD_SC_MCU7T5V0__FILL_1
X59 clkbuf_0_clk/Z _17_/CLK VDD VDD VSS VSS GF180MCU_FD_SC_MCU7T5V0__CLKBUF_16
X60 VDD VDD VSS VSS GF180MCU_FD_SC_MCU7T5V0__FILL_2
X61 VDD VDD VSS VSS GF180MCU_FD_SC_MCU7T5V0__FILL_2
X62 VDD VSS GF180MCU_FD_SC_MCU7T5V0__FILLTIE
X63 VDD VDD VSS VSS GF180MCU_FD_SC_MCU7T5V0__FILLCAP_16
X64 VDD VDD VSS VSS GF180MCU_FD_SC_MCU7T5V0__FILLCAP_16
X65 VDD VDD VSS VSS GF180MCU_FD_SC_MCU7T5V0__FILLCAP_4
X66 VDD VDD VSS VSS GF180MCU_FD_SC_MCU7T5V0__FILLCAP_4
X67 VDD VDD VSS VSS GF180MCU_FD_SC_MCU7T5V0__FILL_1
X68 VDD VDD VSS VSS GF180MCU_FD_SC_MCU7T5V0__FILL_1
X69 _19_/D _19_/CLK _19_/Q VDD VDD VSS VSS GF180MCU_FD_SC_MCU7T5V0__DFFQ_1
X70 VDD VDD VSS VSS GF180MCU_FD_SC_MCU7T5V0__FILLCAP_16
X71 VDD VDD VSS VSS GF180MCU_FD_SC_MCU7T5V0__FILLCAP_16
X72 VDD VSS GF180MCU_FD_SC_MCU7T5V0__FILLTIE
X73 _18_/D _19_/CLK _18_/Q VDD VDD VSS VSS GF180MCU_FD_SC_MCU7T5V0__DFFQ_1
X74 _17_/D _17_/CLK _17_/Q VDD VDD VSS VSS GF180MCU_FD_SC_MCU7T5V0__DFFQ_1
X75 VDD VDD VSS VSS GF180MCU_FD_SC_MCU7T5V0__FILL_1
X76 VDD VSS GF180MCU_FD_SC_MCU7T5V0__FILLTIE
X77 VDD VDD VSS VSS GF180MCU_FD_SC_MCU7T5V0__FILLCAP_16
X78 VDD VDD VSS VSS GF180MCU_FD_SC_MCU7T5V0__FILL_2
X79 _16_/D _17_/CLK _16_/Q VDD VDD VSS VSS GF180MCU_FD_SC_MCU7T5V0__DFFQ_1
X80 VDD VSS GF180MCU_FD_SC_MCU7T5V0__ENDCAP
X81 clkbuf_0_clk/Z _19_/CLK VDD VDD VSS VSS GF180MCU_FD_SC_MCU7T5V0__CLKBUF_16
X82 VDD VDD VSS VSS GF180MCU_FD_SC_MCU7T5V0__FILL_2
X83 _15_/A1 _15_/A2 _17_/D VDD VDD VSS VSS GF180MCU_FD_SC_MCU7T5V0__NOR2_1
X84 VDD VSS GF180MCU_FD_SC_MCU7T5V0__ENDCAP
X85 VDD VDD VSS VSS GF180MCU_FD_SC_MCU7T5V0__FILLCAP_4
X86 VDD VDD VSS VSS GF180MCU_FD_SC_MCU7T5V0__FILLCAP_4
X87 _16_/Q _17_/Q _15_/A2 VDD VDD VSS VSS GF180MCU_FD_SC_MCU7T5V0__XNOR2_1
X88 VDD VDD VSS VSS GF180MCU_FD_SC_MCU7T5V0__FILL_1
X89 _16_/Q _15_/A1 _16_/D VDD VDD VSS VSS GF180MCU_FD_SC_MCU7T5V0__NOR2_1
X90 VDD VSS GF180MCU_FD_SC_MCU7T5V0__ENDCAP
X91 VDD VSS GF180MCU_FD_SC_MCU7T5V0__FILLTIE
X92 VDD VDD VSS VSS GF180MCU_FD_SC_MCU7T5V0__FILLCAP_8
X93 _15_/A1 _12_/A2 _19_/D VDD VDD VSS VSS GF180MCU_FD_SC_MCU7T5V0__NOR2_1
X94 VDD VDD VSS VSS GF180MCU_FD_SC_MCU7T5V0__FILLCAP_8
X95 VDD VSS GF180MCU_FD_SC_MCU7T5V0__FILLTIE
X96 VDD VSS GF180MCU_FD_SC_MCU7T5V0__FILLTIE
X97 VDD VDD VSS VSS GF180MCU_FD_SC_MCU7T5V0__FILLCAP_16
X98 _19_/Q _09_/Z _12_/A2 VDD VDD VSS VSS GF180MCU_FD_SC_MCU7T5V0__XNOR2_1
X99 VDD VDD VSS VSS GF180MCU_FD_SC_MCU7T5V0__FILL_2
X100 VDD VDD VSS VSS GF180MCU_FD_SC_MCU7T5V0__FILL_2
X101 _16_/Q q[0] VDD VDD VSS VSS GF180MCU_FD_SC_MCU7T5V0__DLYB_1
X102 VDD VDD VSS VSS GF180MCU_FD_SC_MCU7T5V0__FILLCAP_8
X103 _15_/A1 _10_/A2 _09_/Z _18_/D VDD VDD VSS VSS GF180MCU_FD_SC_MCU7T5V0__NOR3_1
X104 VDD VDD VSS VSS GF180MCU_FD_SC_MCU7T5V0__FILL_2
X105 VDD VDD VSS VSS GF180MCU_FD_SC_MCU7T5V0__FILLCAP_16
X106 VDD VDD VSS VSS GF180MCU_FD_SC_MCU7T5V0__FILLCAP_4
X107 _17_/Q q[1] VDD VDD VSS VSS GF180MCU_FD_SC_MCU7T5V0__DLYB_1
X108 VDD VSS GF180MCU_FD_SC_MCU7T5V0__FILLTIE
X109 _18_/Q q[2] VDD VDD VSS VSS GF180MCU_FD_SC_MCU7T5V0__DLYB_1
X110 VDD VSS GF180MCU_FD_SC_MCU7T5V0__FILLTIE
X111 VDD VDD VSS VSS GF180MCU_FD_SC_MCU7T5V0__FILLCAP_16
X112 VDD VSS GF180MCU_FD_SC_MCU7T5V0__ENDCAP
X113 _19_/Q q[3] VDD VDD VSS VSS GF180MCU_FD_SC_MCU7T5V0__DLYB_1
X114 VDD VSS GF180MCU_FD_SC_MCU7T5V0__ENDCAP
.ends counter
