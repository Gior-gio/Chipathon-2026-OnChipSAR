** sch_path: /foss/designs/Chipathon-2026-OnChipSAR/designs/sar_adc/top/hybrid_dac/xschem/hybrid_dac.sch
.subckt hybrid_dac VSS VDD VRP VRN SW1p[8] SW1p[7] SW1p[6] SW1p[5] SW1p[4] SW1p[3] SW1p[2] SW1p[1] SW1p[0] SW0p[8] SW0p[7] SW0p[6]
+ SW0p[5] SW0p[4] SW0p[3] SW0p[2] SW0p[1] SW0p[0] SW1n[8] SW1n[7] SW1n[6] SW1n[5] SW1n[4] SW1n[3] SW1n[2] SW1n[1] SW1n[0] SW0n[8] SW0n[7]
+ SW0n[6] SW0n[5] SW0n[4] SW0n[3] SW0n[2] SW0n[1] SW0n[0] VIN VX VY
*.PININFO VSS:B VDD:B VRP:I VRN:I SW1p[8:0]:B SW0p[8:0]:B SW1n[8:0]:B SW0n[8:0]:B VIN:B VX:O VY:O
xRDAC VCM VRX[1] VRX[0] VRY[1] VRY[0] VRP VRN VSS rdac
xCDAC CP[8] CP[3] CP[5] CP[1] CP[0] CP[4] CP[6] CP[7] CP[2] CN[2] CN[1] CN[3] CN[8] CN[7] CN[6] CN[5] CN[4] CN[0] VX VY cdac
xSWP4 VDD SW1p[4] SW0p[4] VSS CP[4] VRP VRP VRN VRP dac_sw_4state_A
xSWP5 VDD SW1p[5] SW0p[5] VSS CP[5] VRP VRP VRN VRP dac_sw_4state_B
xSWP6 VDD SW1p[6] SW0p[6] VSS CP[6] VRP VRP VRN VRP dac_sw_4state_B
xSWP7 VDD SW1p[7] SW0p[7] VSS CP[7] VRP VRP VRN VRP dac_sw_4state_B
xSWP8 VDD SW1p[8] SW0p[8] VSS CP[8] VRP VRP VRN VRP dac_sw_4state_B
xSWN4 VDD SW1n[4] SW0n[4] VSS CN[4] VIN VRN VRP VRP dac_sw_4state_A
xSWN5 VDD SW1n[5] SW0n[5] VSS CN[5] VIN VRN VRP VRP dac_sw_4state_B
xSWN6 VDD SW1n[6] SW0n[6] VSS CN[6] VIN VRN VRP VRP dac_sw_4state_B
xSWN7 VDD SW1n[7] SW0n[7] VSS CN[7] VIN VRN VRP VRP dac_sw_4state_B
xSWN8 VDD SW1n[8] SW0n[8] VSS CN[8] VIN VRN VRP VRP dac_sw_4state_B
xSWP0 VDD SW1p[0] SW0p[0] VSS CP[0] VRP VRX[0] VCM VRP dac_sw_4state_A
xSWP1 VDD SW1p[1] SW0p[1] VSS CP[1] VRP VRX[0] VCM VRP dac_sw_4state_A
xSWP2 VDD SW1p[2] SW0p[2] VSS CP[2] VRP VRX[0] VRY[0] VRP dac_sw_4state_A
xSWP3 VDD SW1p[3] SW0p[3] VSS CP[3] VRP VRX[1] VRY[1] VRP dac_sw_4state_A
xSWN0 VDD SW1n[0] SW0n[0] VSS CN[0] VIN VCM VRX[0] VRP dac_sw_4state_A
xSWN1 VDD SW1n[1] SW0n[1] VSS CN[1] VIN VCM VRX[0] VRP dac_sw_4state_A
xSWN2 VDD SW1n[2] SW0n[2] VSS CN[2] VIN VRY[0] VRX[0] VRP dac_sw_4state_A
xSWN3 VDD SW1n[3] SW0n[3] VSS CN[3] VIN VRY[1] VRX[1] VRP dac_sw_4state_A
* noconn VCM
.ends

* expanding   symbol:  designs/sar_adc/dac/rdac/xschem/rdac.sym # of pins=6
** sym_path: /foss/designs/Chipathon-2026-OnChipSAR/designs/sar_adc/dac/rdac/xschem/rdac.sym
** sch_path: /foss/designs/Chipathon-2026-OnChipSAR/designs/sar_adc/dac/rdac/xschem/rdac.sch
.subckt rdac VCM VRX[1] VRX[0] VRY[1] VRY[0] VRP VRN VSS
*.PININFO VRN:I VRP:I VCM:B VRY[1:0]:B VRX[1:0]:B VSS:B
*  RN0 -  ppolyf_u_3k  IS MISSING !!!!
*  RN1 -  ppolyf_u_3k  IS MISSING !!!!
*  RN2 -  ppolyf_u_3k  IS MISSING !!!!
*  RN3 -  ppolyf_u_3k  IS MISSING !!!!
*  RP0 -  ppolyf_u_3k  IS MISSING !!!!
*  RP1 -  ppolyf_u_3k  IS MISSING !!!!
*  RP2 -  ppolyf_u_3k  IS MISSING !!!!
*  RP3 -  ppolyf_u_3k  IS MISSING !!!!
*  RDC[3],RDC[2],RDC[1],RDC[0] -  ppolyf_u_3k  IS MISSING !!!!
*  RDB[7],RDB[6],RDB[5],RDB[4],RDB[3],RDB[2],RDB[1],RDB[0] -  ppolyf_u_3k  IS MISSING !!!!
*  RDA[3],RDA[2],RDA[1],RDA[0] -  ppolyf_u_3k  IS MISSING !!!!
.ends

* expanding   symbol:  designs/sar_adc/dac/cdac/xschem/cdac.sym # of pins=20
** sym_path: /foss/designs/Chipathon-2026-OnChipSAR/designs/sar_adc/dac/cdac/xschem/cdac.sym
** sch_path: /foss/designs/Chipathon-2026-OnChipSAR/designs/sar_adc/dac/cdac/xschem/cdac.sch
.subckt cdac CP[8] CP[3] CP[5] CP[1] CP[0] CP[4] CP[6] CP[7] CP[2] CN[2] CN[1] CN[3] CN[8] CN[7] CN[6] CN[5] CN[4] CN[0] VX VY
*.PININFO VX:B VY:B CP[0]:I CP[1]:I CP[2]:I CP[3]:I CP[4]:I CP[5]:I CP[6]:I CP[7]:I CP[8]:I CN[0]:I CN[1]:I CN[2]:I CN[3]:I
*+ CN[4]:I CN[5]:I CN[6]:I CN[7]:I CN[8]:I
*  CP8 -  cap_mim_2f0fF  IS MISSING !!!!
*  CP7 -  cap_mim_2f0fF  IS MISSING !!!!
*  CP6 -  cap_mim_2f0fF  IS MISSING !!!!
*  CP5 -  cap_mim_2f0fF  IS MISSING !!!!
*  CP4 -  cap_mim_2f0fF  IS MISSING !!!!
*  CP3 -  cap_mim_2f0fF  IS MISSING !!!!
*  CP2 -  cap_mim_2f0fF  IS MISSING !!!!
*  CP1 -  cap_mim_2f0fF  IS MISSING !!!!
*  CP01 -  cap_mim_2f0fF  IS MISSING !!!!
*  CN8 -  cap_mim_2f0fF  IS MISSING !!!!
*  CN7 -  cap_mim_2f0fF  IS MISSING !!!!
*  CN6 -  cap_mim_2f0fF  IS MISSING !!!!
*  CN5 -  cap_mim_2f0fF  IS MISSING !!!!
*  CN4 -  cap_mim_2f0fF  IS MISSING !!!!
*  CN3 -  cap_mim_2f0fF  IS MISSING !!!!
*  CN2 -  cap_mim_2f0fF  IS MISSING !!!!
*  CN1 -  cap_mim_2f0fF  IS MISSING !!!!
*  CN01 -  cap_mim_2f0fF  IS MISSING !!!!
*  CP00 -  cap_mim_2f0fF  IS MISSING !!!!
*  CN00 -  cap_mim_2f0fF  IS MISSING !!!!
.ends

* expanding   symbol:  designs/sar_adc/dac/dac_sw_4state_A/xschem/dac_sw_4state_A.sym # of pins=8
** sym_path: /foss/designs/Chipathon-2026-OnChipSAR/designs/sar_adc/dac/dac_sw_4state_A/xschem/dac_sw_4state_A.sym
** sch_path: /foss/designs/Chipathon-2026-OnChipSAR/designs/sar_adc/dac/dac_sw_4state_A/xschem/dac_sw_4state_A.sch
.subckt dac_sw_4state_A VDD s[1] s[0] VSS CI VSAM VBP VBN VRST
*.PININFO s[1:0]:I VDD:B VSS:B VRST:I CI:B VSAM:I VBP:I VBN:I
xBP VDD VSS BP VBP CI BPN dac_sw_1state_A
xBN VDD VSS BN VBN CI BNN dac_sw_1state_A
xRST VDD VSS RST VRST CI RSTN dac_sw_1state_A
xSAM VDD VSS SAM VSAM CI SAMN dac_sw_1state_A
xNBP VDD VSS s[1] s[0] BPN gate_nand_x1
xBP1 VDD BPN BP VSS gate_inv_x1
xBN1 VDD BNN BN VSS gate_inv_x1
xNBN VDD VSS sn[0] s[1] BNN gate_nand_x1
xNRST VDD VSS sn[1] s[0] RSTN gate_nand_x1
xIRST VDD RSTN RST VSS gate_inv_x1
xISAM VDD SAMN SAM VSS gate_inv_x1
xNSAM VDD VSS sn[0] sn[1] SAMN gate_nand_x1
xS0 VDD s[0] sn[0] VSS gate_inv_x1
xS1 VDD s[1] sn[1] VSS gate_inv_x1
.ends

* expanding   symbol:  designs/sar_adc/dac/dac_sw_4state_B/xschem/dac_sw_4state_B.sym # of pins=8
** sym_path: /foss/designs/Chipathon-2026-OnChipSAR/designs/sar_adc/dac/dac_sw_4state_B/xschem/dac_sw_4state_B.sym
** sch_path: /foss/designs/Chipathon-2026-OnChipSAR/designs/sar_adc/dac/dac_sw_4state_B/xschem/dac_sw_4state_B.sch
.subckt dac_sw_4state_B VDD s[1] s[0] VSS CI VSAM VBP VBN VRST
*.PININFO VRST:I CI:B VSAM:I VBP:I VBN:I s[1:0]:I VDD:B VSS:B
xBP VDD VSS BP VBP CI BPN dac_sw_1state_B
xBN VDD VSS BN VBN CI BNN dac_sw_1state_B
xRST VDD VSS RST VRST CI RSTN dac_sw_1state_B
xSAM VDD VSS SAM VSAM CI SAMN dac_sw_1state_B
xNBP VDD VSS s[1] s[0] BPN gate_nand_x1
xBP1 VDD BPN BP VSS gate_inv_x1
xBN1 VDD BNN BN VSS gate_inv_x1
xNBN VDD VSS sn[0] s[1] BNN gate_nand_x1
xNRST VDD VSS sn[1] s[0] RSTN gate_nand_x1
xIRST VDD RSTN RST VSS gate_inv_x1
xISAM VDD SAMN SAM VSS gate_inv_x1
xNSAM VDD VSS sn[0] sn[1] SAMN gate_nand_x1
xS0 VDD s[0] sn[0] VSS gate_inv_x1
xS1 VDD s[1] sn[1] VSS gate_inv_x1
.ends

* expanding   symbol:  designs/sar_adc/dac/dac_sw_1state_A/xschem/dac_sw_1state_A.sym # of pins=6
** sym_path: /foss/designs/Chipathon-2026-OnChipSAR/designs/sar_adc/dac/dac_sw_1state_A/xschem/dac_sw_1state_A.sym
** sch_path: /foss/designs/Chipathon-2026-OnChipSAR/designs/sar_adc/dac/dac_sw_1state_A/xschem/dac_sw_1state_A.sch
.subckt dac_sw_1state_A VDD VSS CLK VIN VOUT CLKN
*.PININFO VIN:B VOUT:B CLK:B CLKN:B VSS:B VDD:B
*  MSN -  nfet_03v3  IS MISSING !!!!
*  MSP -  pfet_03v3  IS MISSING !!!!
.ends

* expanding   symbol:  designs/sar_adc/digital/gate_nand_x1/xschem/gate_nand_x1.sym # of pins=5
** sym_path: /foss/designs/Chipathon-2026-OnChipSAR/designs/sar_adc/digital/gate_nand_x1/xschem/gate_nand_x1.sym
** sch_path: /foss/designs/Chipathon-2026-OnChipSAR/designs/sar_adc/digital/gate_nand_x1/xschem/gate_nand_x1.sch
.subckt gate_nand_x1 VDD VSS A B out
*.PININFO A:B B:B out:B VDD:B VSS:B
*  M5 -  pfet_03v3  IS MISSING !!!!
*  M6 -  nfet_03v3  IS MISSING !!!!
*  M7 -  pfet_03v3  IS MISSING !!!!
*  M8 -  nfet_03v3  IS MISSING !!!!
.ends

* expanding   symbol:  designs/sar_adc/digital/gate_inv_x1/xschem/gate_inv_x1.sym # of pins=6
** sym_path: /foss/designs/Chipathon-2026-OnChipSAR/designs/sar_adc/digital/gate_inv_x1/xschem/gate_inv_x1.sym
** sch_path: /foss/designs/Chipathon-2026-OnChipSAR/designs/sar_adc/digital/gate_inv_x1/xschem/gate_inv_x1.sch
.subckt gate_inv_x1 VDD in out VSS
*.PININFO out:O in:B VDD:B VSS:B
*  M1 -  nfet_03v3  IS MISSING !!!!
*  M2 -  pfet_03v3  IS MISSING !!!!
.ends

* expanding   symbol:  designs/sar_adc/dac/dac_sw_1state_B/xschem/dac_sw_1state_B.sym # of pins=6
** sym_path: /foss/designs/Chipathon-2026-OnChipSAR/designs/sar_adc/dac/dac_sw_1state_B/xschem/dac_sw_1state_B.sym
** sch_path: /foss/designs/Chipathon-2026-OnChipSAR/designs/sar_adc/dac/dac_sw_1state_B/xschem/dac_sw_1state_B.sch
.subckt dac_sw_1state_B VDD VSS CLK VIN VOUT CLKN
*.PININFO VIN:B VOUT:B CLK:B CLKN:B VSS:B VDD:B
*  MSN -  nfet_03v3  IS MISSING !!!!
*  MSP -  pfet_03v3  IS MISSING !!!!
.ends
