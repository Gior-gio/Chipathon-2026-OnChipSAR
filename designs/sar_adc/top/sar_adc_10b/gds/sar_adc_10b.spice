** sch_path: /foss/designs/Chipathon-2026-OnChipSAR/designs/sar_adc/top/sar_adc_10b/xschem/sar_adc_10b.sch
.subckt sar_adc_10b VIN VDD VSS VRP VX B[9] B[8] B[7] B[6] B[5] B[4] B[3] B[2] B[1] B[0] SAMP CLK VY VRN
*.PININFO VSS:B VDD:B VRP:I VRN:I CLK:I SAMP:I B[9:0]:O VIN:I VX:B VY:B
xREG VDD CLK SAMP COMP SW0[8] SW0[7] SW0[6] SW0[5] SW0[4] SW0[3] SW0[2] SW0[1] SW0[0] B[9] B[8] B[7] B[6] B[5] B[4] B[3] B[2] B[1]
+ B[0] SW1[8] SW1[7] SW1[6] SW1[5] SW1[4] SW1[3] SW1[2] SW1[1] SW1[0] VSS logica_digital_TOP
xCORE SW1[8] SW1[7] SW1[6] SW1[5] SW1[4] SW1[3] SW1[2] SW1[1] SW1[0] SW0[8] SW0[7] SW0[6] SW0[5] SW0[4] SW0[3] SW0[2] SW0[1]
+ SW0[0] SW1[8] SW1[7] SW1[6] SW1[5] SW1[4] SW1[3] SW1[2] SW1[1] SW1[0] SW0[8] SW0[7] SW0[6] SW0[5] SW0[4] SW0[3] SW0[2] SW0[1] SW0[0] VX
+ COMP VY VIN VDD VSS VRP SAMP CLK VRN sar_adc_10b_core
.ends

* expanding   symbol:  designs/sar_adc/digital/logica_digital_TOP/xschem/logica_digital_TOP.sym # of pins=8
** sym_path: /foss/designs/Chipathon-2026-OnChipSAR/designs/sar_adc/digital/logica_digital_TOP/xschem/logica_digital_TOP.sym
** sch_path: /foss/designs/Chipathon-2026-OnChipSAR/designs/sar_adc/digital/logica_digital_TOP/xschem/logica_digital_TOP.sch
.subckt logica_digital_TOP VDD CLK SAMP Vcomp SW0[8] SW0[7] SW0[6] SW0[5] SW0[4] SW0[3] SW0[2] SW0[1] SW0[0] B[9] B[8] B[7] B[6]
+ B[5] B[4] B[3] B[2] B[1] B[0] SW1[8] SW1[7] SW1[6] SW1[5] SW1[4] SW1[3] SW1[2] SW1[1] SW1[0] VSS
*.PININFO VDD:B VSS:B SAMP:B CLK:B Vcomp:B B[9:0]:B SW0[8:0]:B SW1[8:0]:B
xFFR[10] CLK VDD VDD VSS CK[10] SAMPN FF_D
xFFR[9] CLK CK[10] VDD VSS CK[9] SAMPN FF_D
xFFR[8] CLK CK[9] VDD VSS CK[8] SAMPN FF_D
xFFR[7] CLK CK[8] VDD VSS CK[7] SAMPN FF_D
xFFR[6] CLK CK[7] VDD VSS CK[6] SAMPN FF_D
xFFR[5] CLK CK[6] VDD VSS CK[5] SAMPN FF_D
xFFR[4] CLK CK[5] VDD VSS CK[4] SAMPN FF_D
xFFR[3] CLK CK[4] VDD VSS CK[3] SAMPN FF_D
xFFR[2] CLK CK[3] VDD VSS CK[2] SAMPN FF_D
xFFR[1] CLK CK[2] VDD VSS CK[1] SAMPN FF_D
xFFR[0] CLK CK[1] VDD VSS CK[0] SAMPN FF_D
xFFSET[9] CK[9] VCB VDD VSS BN[9] SAMPN B[9] SET flip_flop_set
xFFSET[8] CK[8] VCB VDD VSS BN[8] SAMPN B[8] SET flip_flop_set
xFFSET[7] CK[7] VCB VDD VSS BN[7] SAMPN B[7] SET flip_flop_set
xFFSET[6] CK[6] VCB VDD VSS BN[6] SAMPN B[6] SET flip_flop_set
xFFSET[5] CK[5] VCB VDD VSS BN[5] SAMPN B[5] SET flip_flop_set
xFFSET[4] CK[4] VCB VDD VSS BN[4] SAMPN B[4] SET flip_flop_set
xFFSET[3] CK[3] VCB VDD VSS BN[3] SAMPN B[3] SET flip_flop_set
xFFSET[2] CK[2] VCB VDD VSS BN[2] SAMPN B[2] SET flip_flop_set
xFFSET[1] CK[1] VCB VDD VSS BN[1] SAMPN B[1] SET flip_flop_set
xFFSET[0] CK[0] VCB VDD VSS BN[0] SAMPN B[0] SET flip_flop_set
x3 SAMPN SET VDD VSS edge_detector
xbuffersw0[8] VDD SW0[8] BN[9] VSS gate_buf_x1
xbuffersw0[7] VDD SW0[7] BN[8] VSS gate_buf_x1
xbuffersw0[6] VDD SW0[6] BN[7] VSS gate_buf_x1
xbuffersw0[5] VDD SW0[5] BN[6] VSS gate_buf_x1
xbuffersw0[4] VDD SW0[4] BN[5] VSS gate_buf_x1
xbuffersw0[3] VDD SW0[3] BN[4] VSS gate_buf_x1
xbuffersw0[2] VDD SW0[2] BN[3] VSS gate_buf_x1
xbuffersw0[1] VDD SW0[1] BN[2] VSS gate_buf_x1
xbuffersw0[0] VDD SW0[0] BN[1] VSS gate_buf_x1
xbuffersw1[8] VDD SW1[8] CK[9] VSS gate_buf_x1
xbuffersw1[7] VDD SW1[7] CK[8] VSS gate_buf_x1
xbuffersw1[6] VDD SW1[6] CK[7] VSS gate_buf_x1
xbuffersw1[5] VDD SW1[5] CK[6] VSS gate_buf_x1
xbuffersw1[4] VDD SW1[4] CK[5] VSS gate_buf_x1
xbuffersw1[3] VDD SW1[3] CK[4] VSS gate_buf_x1
xbuffersw1[2] VDD SW1[2] CK[3] VSS gate_buf_x1
xbuffersw1[1] VDD SW1[1] CK[2] VSS gate_buf_x1
xbuffersw1[0] VDD SW1[0] CK[1] VSS gate_buf_x1
xbuffer VDD VCB Vcomp VSS gate_buf_x1
xINV_SAMP VDD SAMP SAMPN VSS gate_inv_x2
.ends

* expanding   symbol:  designs/sar_adc/top/sar_adc_10b_core/xschem/sar_adc_10b_core.sym # of pins=14
** sym_path: /foss/designs/Chipathon-2026-OnChipSAR/designs/sar_adc/top/sar_adc_10b_core/xschem/sar_adc_10b_core.sym
** sch_path: /foss/designs/Chipathon-2026-OnChipSAR/designs/sar_adc/top/sar_adc_10b_core/xschem/sar_adc_10b_core.sch
.subckt sar_adc_10b_core SW1p[8] SW1p[7] SW1p[6] SW1p[5] SW1p[4] SW1p[3] SW1p[2] SW1p[1] SW1p[0] SW0p[8] SW0p[7] SW0p[6] SW0p[5]
+ SW0p[4] SW0p[3] SW0p[2] SW0p[1] SW0p[0] SW1n[8] SW1n[7] SW1n[6] SW1n[5] SW1n[4] SW1n[3] SW1n[2] SW1n[1] SW1n[0] SW0n[8] SW0n[7] SW0n[6]
+ SW0n[5] SW0n[4] SW0n[3] SW0n[2] SW0n[1] SW0n[0] VX COMP VY VIN VDD VSS VRP SAMP CLK VRN
*.PININFO VSS:B VDD:B VRP:I VRN:I VIN:I VY:B VX:B SAMP:I COMP:B SW1p[8:0]:B SW0p[8:0]:B SW1n[8:0]:B SW0n[8:0]:B CLK:I
xRDAC VCM VRX[1] VRX[0] VRY[1] VRY[0] VRP VRN VSS rdac
xSHP VDD VSS SAMP VIN VX bootstrapped
xSHN VDD VSS SAMP VRN VY bootstrapped
xCOMP VDD CLK COMPN COMP VY VX VSS strongARM
xCDAC CP[8] CP[3] CP[5] CP[1] CP[0] CP[4] CP[6] CP[7] CP[2] CN[2] CN[1] CN[3] CN[8] CN[7] CN[6] CN[5] CN[4] CN[0] VX VY cdac
xSWP4 VDD SW1p[4] SW0p[4] VSS CP[4] VRP VRP VRN VRP dac_sw_4state_A
xSWP5 VDD SW1p[5] SW0p[5] VSS CP[5] VRP VRP VRN VRP dac_sw_4state_B
xSWP6 VDD SW1p[6] SW0p[6] VSS CP[6] VRP VRP VRN VRP dac_sw_4state_B
xSWP7 VDD SW1p[7] SW0p[7] VSS CP[7] VRP VRP VRN VRP dac_sw_4state_B
xSWP8 VDD SW1p[8] SW0p[8] VSS CP[8] VRP VRP VRN VRP dac_sw_4state_B
xSWN4 VDD SW1n[4] SW0n[4] VSS CN[4] VIN VRN VRP VRP dac_sw_4state_A
xSWN5 VDD SW1n[5] SW0n[5] VSS CN[5] VIN VRN VRP VRP dac_sw_4state_B
xSWN6 VDD SW1n[6] SW0n[6] VSS CN[6] VIN VRN VRP VRP dac_sw_4state_B
xSWN7 VDD SW1n[7] SW0n[7] VSS CN[7] VIN VRN VRP VRP dac_sw_4state_B
xSWN8 VDD SW1n[8] SW0n[8] VSS CN[8] VIN VRN VRP VRP dac_sw_4state_B
xSWP0 VDD SW1p[0] SW0p[0] VSS CP[0] VRP VRX[0] VCM VRP dac_sw_4state_A
xSWP1 VDD SW1p[1] SW0p[1] VSS CP[1] VRP VRX[0] VCM VRP dac_sw_4state_A
xSWP2 VDD SW1p[2] SW0p[2] VSS CP[2] VRP VRX[0] VRY[0] VRP dac_sw_4state_A
xSWP3 VDD SW1p[3] SW0p[3] VSS CP[3] VRP VRX[1] VRY[1] VRP dac_sw_4state_A
xSWN0 VDD SW1n[0] SW0n[0] VSS CN[0] VIN VCM VRX[0] VRP dac_sw_4state_A
xSWN1 VDD SW1n[1] SW0n[1] VSS CN[1] VIN VCM VRX[0] VRP dac_sw_4state_A
xSWN2 VDD SW1n[2] SW0n[2] VSS CN[2] VIN VRY[0] VRX[0] VRP dac_sw_4state_A
xSWN3 VDD SW1n[3] SW0n[3] VSS CN[3] VIN VRY[1] VRX[1] VRP dac_sw_4state_A
* noconn VCM
* noconn COMPN
.ends

* expanding   symbol:  designs/sar_adc/digital/flip_flop/xschem/FF_D.sym # of pins=6
** sym_path: /foss/designs/Chipathon-2026-OnChipSAR/designs/sar_adc/digital/flip_flop/xschem/FF_D.sym
** sch_path: /foss/designs/Chipathon-2026-OnChipSAR/designs/sar_adc/digital/flip_flop/xschem/FF_D.sch
.subckt FF_D CLK D VDD VSS Q RN
*.PININFO VDD:B VSS:B CLK:B D:B RN:B Q:B
xslave1 CLKN D VDD tg1 CLK VSS gate_tg_x1
xmaster2 CLK net1 VDD net3 CLKN VSS gate_tg_x1
xslave2 CLKN Q VDD net3 CLK VSS gate_tg_x1
xmaster1 CLK net1 VDD tg1 CLKN VSS gate_tg_x1
xINV_CLK VDD CLK CLKN VSS gate_inv_x1
xgate_inv1 VDD nand1 net1 VSS gate_inv_x1
xgate_inv2 VDD net2 Q VSS gate_inv_x1
xgate_nand1 VDD VSS RN tg1 nand1 gate_nand_x1
xgate_nand2 VDD VSS RN net3 net2 gate_nand_x1
.ends

* expanding   symbol:  designs/sar_adc/digital/flip_flop_set/xschem/flip_flop_set.sym # of pins=8
** sym_path: /foss/designs/Chipathon-2026-OnChipSAR/designs/sar_adc/digital/flip_flop_set/xschem/flip_flop_set.sym
** sch_path: /foss/designs/Chipathon-2026-OnChipSAR/designs/sar_adc/digital/flip_flop_set/xschem/flip_flop_set.sch
.subckt flip_flop_set CLK D VDD VSS Q RN QN SN
*.PININFO VDD:B VSS:B CLK:B D:B RN:B Q:B QN:B SN:B
xslave1 CLKN D VDD tg1 CLK VSS gate_tg_x1
xslave2 CLKN Q VDD X CLK VSS gate_tg_x1
xmaster CLK B VDD tg1 CLKN VSS gate_tg_x1
xmaster1 CLK B VDD X CLKN VSS gate_tg_x1
xINV_CLK VDD CLK CLKN VSS gate_inv_x1
xgate_nand1 VDD VSS RN tg1 A gate_nand_x1
xgate_nand2 VDD VSS SN A B gate_nand_x1
xgate_nand3 VDD VSS RN X Y gate_nand_x1
xgate_nand4 VDD VSS SN Y Q gate_nand_x1
xINVQ VDD Q QN VSS gate_inv_x1
.ends

* expanding   symbol:  designs/sar_adc/digital/edge_detector/xschem/edge_detector.sym # of pins=4
** sym_path: /foss/designs/Chipathon-2026-OnChipSAR/designs/sar_adc/digital/edge_detector/xschem/edge_detector.sym
** sch_path: /foss/designs/Chipathon-2026-OnChipSAR/designs/sar_adc/digital/edge_detector/xschem/edge_detector.sch
.subckt edge_detector IN OUT VDD VSS
*.PININFO VDD:B VSS:B IN:I OUT:O
xNAND VDD VSS P4 IN EDGE gate_nand_x1
xBUF VDD OUT EDGE VSS gate_buf_x1
xDEL VDD IN P4 VSS gate_delay_edge
.ends

* expanding   symbol:  designs/sar_adc/digital/gate_buf_x1/xschem/gate_buf_x1.sym # of pins=4
** sym_path: /foss/designs/Chipathon-2026-OnChipSAR/designs/sar_adc/digital/gate_buf_x1/xschem/gate_buf_x1.sym
** sch_path: /foss/designs/Chipathon-2026-OnChipSAR/designs/sar_adc/digital/gate_buf_x1/xschem/gate_buf_x1.sch
.subckt gate_buf_x1 VDD B A VSS
*.PININFO B:O A:I VDD:B VSS:B
MN1 net1 A VSS VSS nfet_03v3 L=0.28u W=0.5u nf=1
MP1 net1 A VDD VDD pfet_03v3 L=0.28u W=0.5u nf=1 m=2
MN2 B net1 VSS VSS nfet_03v3 L=0.28u W=0.5u nf=1 m=3
MP2 B net1 VDD VDD pfet_03v3 L=0.28u W=0.5u nf=1 m=6
.ends

* expanding   symbol:  designs/sar_adc/digital/gate_inv_x2/xschem/gate_inv_x2.sym # of pins=6
** sym_path: /foss/designs/Chipathon-2026-OnChipSAR/designs/sar_adc/digital/gate_inv_x2/xschem/gate_inv_x2.sym
** sch_path: /foss/designs/Chipathon-2026-OnChipSAR/designs/sar_adc/digital/gate_inv_x2/xschem/gate_inv_x2.sch
.subckt gate_inv_x2 VDD in out VSS
*.PININFO out:O in:B VDD:B VSS:B
M1 out in VSS VSS nfet_03v3 L=0.28u W=0.5u nf=1
M2 out in VDD VDD pfet_03v3 L=0.28u W=0.5u nf=1 m=2
.ends

* expanding   symbol:  designs/sar_adc/dac/rdac/xschem/rdac.sym # of pins=6
** sym_path: /foss/designs/Chipathon-2026-OnChipSAR/designs/sar_adc/dac/rdac/xschem/rdac.sym
** sch_path: /foss/designs/Chipathon-2026-OnChipSAR/designs/sar_adc/dac/rdac/xschem/rdac.sch
.subckt rdac VCM VRX[1] VRX[0] VRY[1] VRY[0] VRP VRN VSS
*.PININFO VRN:I VRP:I VCM:B VRY[1:0]:B VRX[1:0]:B VSS:B
XRN0 VRY[0] VCM VSS ppolyf_u_1k r_width=2e-6 r_length=3e-6
XRN1 VRY[1] VRY[0] VSS ppolyf_u_1k r_width=2e-6 r_length=3e-6
XRN2 net1 VRY[1] VSS ppolyf_u_1k r_width=2e-6 r_length=3e-6
XRN3 net1 VRN VSS ppolyf_u_1k r_width=2e-6 r_length=3e-6
XRP0 VRX[0] VCM VSS ppolyf_u_1k r_width=2e-6 r_length=3e-6
XRP1 VRX[1] VRX[0] VSS ppolyf_u_1k r_width=2e-6 r_length=3e-6
XRP2 net2 VRX[1] VSS ppolyf_u_1k r_width=2e-6 r_length=3e-6
XRP3 VRP net2 VSS ppolyf_u_1k r_width=2e-6 r_length=3e-6
XRDC[3] VSS VSS VSS ppolyf_u_1k r_width=0.8e-6 r_length=3e-6
XRDC[2] VSS VSS VSS ppolyf_u_1k r_width=0.8e-6 r_length=3e-6
XRDC[1] VSS VSS VSS ppolyf_u_1k r_width=0.8e-6 r_length=3e-6
XRDC[0] VSS VSS VSS ppolyf_u_1k r_width=0.8e-6 r_length=3e-6
XRDB[7] VSS VSS VSS ppolyf_u_1k r_width=2e-6 r_length=0.8e-6
XRDB[6] VSS VSS VSS ppolyf_u_1k r_width=2e-6 r_length=0.8e-6
XRDB[5] VSS VSS VSS ppolyf_u_1k r_width=2e-6 r_length=0.8e-6
XRDB[4] VSS VSS VSS ppolyf_u_1k r_width=2e-6 r_length=0.8e-6
XRDB[3] VSS VSS VSS ppolyf_u_1k r_width=2e-6 r_length=0.8e-6
XRDB[2] VSS VSS VSS ppolyf_u_1k r_width=2e-6 r_length=0.8e-6
XRDB[1] VSS VSS VSS ppolyf_u_1k r_width=2e-6 r_length=0.8e-6
XRDB[0] VSS VSS VSS ppolyf_u_1k r_width=2e-6 r_length=0.8e-6
XRDA[3] VSS VSS VSS ppolyf_u_1k r_width=0.8e-6 r_length=0.8e-6
XRDA[2] VSS VSS VSS ppolyf_u_1k r_width=0.8e-6 r_length=0.8e-6
XRDA[1] VSS VSS VSS ppolyf_u_1k r_width=0.8e-6 r_length=0.8e-6
XRDA[0] VSS VSS VSS ppolyf_u_1k r_width=0.8e-6 r_length=0.8e-6
.ends

* expanding   symbol:  designs/sar_adc/samplehold/bootstrapped/xschem/bootstrapped.sym # of pins=5
** sym_path: /foss/designs/Chipathon-2026-OnChipSAR/designs/sar_adc/samplehold/bootstrapped/xschem/bootstrapped.sym
** sch_path: /foss/designs/Chipathon-2026-OnChipSAR/designs/sar_adc/samplehold/bootstrapped/xschem/bootstrapped.sch
.subckt bootstrapped VDD VSS CLK VIN VOUT
*.PININFO CLK:B VSS:B VDD:B VOUT:B VIN:B
XBS_SW_N7 net1 CLKN VSS VSS nfet_03v3 L=0.28u W=0.5u nf=1 m=2
XBS_SW_N3 cc VX Vcc VSS nfet_03v3 L=0.28u W=0.5u nf=1
XBS_SW_P3 VX cc Vc Vc pfet_03v3 L=0.28u W=1u nf=1
XBS_SW_N6 VX VDD net1 VSS nfet_03v3 L=0.28u W=0.5u nf=1 m=2
XBS_SW_P1 Vc VX VDD Vc pfet_03v3 L=0.28u W=1u nf=1
XBS_SW_N1 VOUT VX VIN VSS nfet_03v3 L=0.28u W=1.5u nf=1
XBS_SW_N2 VIN VX Vcc VSS nfet_03v3 L=0.28u W=0.5u nf=1
XBS_SW_N5 Vcc CLKN VSS VSS nfet_03v3 L=0.28u W=0.5u nf=1
XBS_SW_N4 cc CLK Vcc VSS nfet_03v3 L=0.28u W=0.5u nf=1
XBS_SW_P2 cc CLK VDD VDD pfet_03v3 L=0.28u W=0.5u nf=1 m=2
XCAP_BOOT Vc Vcc cap_mim_2f0fF c_width=11e-6 c_length=9.1e-6
M1 CLKN CLK VSS VSS nfet_03v3 L=0.28u W=0.5u nf=1
M2 CLKN CLK VDD VDD pfet_03v3 L=0.28u W=0.5u nf=1 m=2
.ends

* expanding   symbol:  designs/sar_adc/comparator/StrongARM/xschem/strongARM.sym # of pins=7
** sym_path: /foss/designs/Chipathon-2026-OnChipSAR/designs/sar_adc/comparator/StrongARM/xschem/strongARM.sym
** sch_path: /foss/designs/Chipathon-2026-OnChipSAR/designs/sar_adc/comparator/StrongARM/xschem/strongARM.sch
.subckt strongARM VDD CLK ON OP VIN VIP VSS
*.PININFO VSS:B VDD:B VIN:B VIP:B OP:B CLK:B ON:B
MTAIL NT CLKK VDD VDD pfet_03v3 L=0.5u W=0.5u nf=1 m=6
M2 AN CLKK VSS VSS nfet_03v3 L=0.5u W=0.5u nf=1 m=2
M3 AP VIP NT VDD pfet_03v3 L=0.5u W=0.5u nf=1 m=4
M4 AN VIN NT VDD pfet_03v3 L=0.5u W=0.5u nf=1 m=4
M5 AP CLKK VSS VSS nfet_03v3 L=0.5u W=0.5u nf=1 m=2
M6 ONN OPP VDD VDD pfet_03v3 L=0.5u W=0.5u nf=1 m=2
M7 OPP ONN VDD VDD pfet_03v3 L=0.5u W=0.5u nf=1 m=2
M8 ONN OPP CN VSS nfet_03v3 L=0.5u W=0.5u nf=1 m=2
M9 OPP ONN CP VSS nfet_03v3 L=0.5u W=0.5u nf=1 m=2
M10 CN AN VSS VSS nfet_03v3 L=0.5u W=0.5u nf=1 m=4
M11 CP AP VSS VSS nfet_03v3 L=0.5u W=0.5u nf=1 m=4
M12 ONN AN VDD VDD pfet_03v3 L=0.5u W=0.5u nf=1 m=2
M13 OPP AP VDD VDD pfet_03v3 L=0.5u W=0.5u nf=1 m=2
M14 CN AN VDD VDD pfet_03v3 L=0.5u W=0.5u nf=1 m=2
M15 CP AP VDD VDD pfet_03v3 L=0.5u W=0.5u nf=1 m=2
x1 VDD CLK CLKN VSS gate_inv_x2
x2 VDD CLKN CLKK VSS gate_inv_x2
x3 VDD ONN ON VSS gate_inv_x2
x4 VDD OPP OP VSS gate_inv_x2
.ends

* expanding   symbol:  designs/sar_adc/dac/cdac/xschem/cdac.sym # of pins=20
** sym_path: /foss/designs/Chipathon-2026-OnChipSAR/designs/sar_adc/dac/cdac/xschem/cdac.sym
** sch_path: /foss/designs/Chipathon-2026-OnChipSAR/designs/sar_adc/dac/cdac/xschem/cdac.sch
.subckt cdac CP[8] CP[3] CP[5] CP[1] CP[0] CP[4] CP[6] CP[7] CP[2] CN[2] CN[1] CN[3] CN[8] CN[7] CN[6] CN[5] CN[4] CN[0] VX VY
*.PININFO VX:B VY:B CP[0]:I CP[1]:I CP[2]:I CP[3]:I CP[4]:I CP[5]:I CP[6]:I CP[7]:I CP[8]:I CN[0]:I CN[1]:I CN[2]:I CN[3]:I
*+ CN[4]:I CN[5]:I CN[6]:I CN[7]:I CN[8]:I
XCP8 CP[8] VX cap_mim_2f0fF c_width=5e-6 c_length=5e-6 m=16
XCP7 CP[7] VX cap_mim_2f0fF c_width=5e-6 c_length=5e-6 m=8
XCP6 CP[6] VX cap_mim_2f0fF c_width=5e-6 c_length=5e-6 m=4
XCP5 CP[5] VX cap_mim_2f0fF c_width=5e-6 c_length=5e-6 m=2
XCP4 CP[4] VX cap_mim_2f0fF c_width=5e-6 c_length=5e-6
XCP3 CP[3] VX cap_mim_2f0fF c_width=5e-6 c_length=5e-6
XCP2 CP[2] VX cap_mim_2f0fF c_width=5e-6 c_length=5e-6
XCP1 CP[1] VX cap_mim_2f0fF c_width=5e-6 c_length=5e-6
XCP01 net1 VX cap_mim_2f0fF c_width=5e-6 c_length=5e-6
XCN8 CN[8] VY cap_mim_2f0fF c_width=5e-6 c_length=5e-6 m=16
XCN7 CN[7] VY cap_mim_2f0fF c_width=5e-6 c_length=5e-6 m=8
XCN6 CN[6] VY cap_mim_2f0fF c_width=5e-6 c_length=5e-6 m=4
XCN5 CN[5] VY cap_mim_2f0fF c_width=5e-6 c_length=5e-6 m=2
XCN4 CN[4] VY cap_mim_2f0fF c_width=5e-6 c_length=5e-6
XCN3 CN[3] VY cap_mim_2f0fF c_width=5e-6 c_length=5e-6
XCN2 CN[2] VY cap_mim_2f0fF c_width=5e-6 c_length=5e-6
XCN1 CN[1] VY cap_mim_2f0fF c_width=5e-6 c_length=5e-6
XCN01 net2 VY cap_mim_2f0fF c_width=5e-6 c_length=5e-6
XCP00 CP[0] net1 cap_mim_2f0fF c_width=5e-6 c_length=5e-6
XCN00 CN[0] net2 cap_mim_2f0fF c_width=5e-6 c_length=5e-6
.ends

* expanding   symbol:  designs/sar_adc/dac/dac_sw_4state_A/xschem/dac_sw_4state_A.sym # of pins=8
** sym_path: /foss/designs/Chipathon-2026-OnChipSAR/designs/sar_adc/dac/dac_sw_4state_A/xschem/dac_sw_4state_A.sym
** sch_path: /foss/designs/Chipathon-2026-OnChipSAR/designs/sar_adc/dac/dac_sw_4state_A/xschem/dac_sw_4state_A.sch
.subckt dac_sw_4state_A VDD s[1] s[0] VSS CI VSAM VBP VBN VRST
*.PININFO s[1:0]:I VDD:B VSS:B VRST:I CI:B VSAM:I VBP:I VBN:I
xBP VDD VSS BP VBP CI BPN dac_sw_1state_A
xBN VDD VSS BN VBN CI BNN dac_sw_1state_A
xRST VDD VSS RST VRST CI RSTN dac_sw_1state_A
xSAM VDD VSS SAM VSAM CI SAMN dac_sw_1state_A
xNBP VDD VSS s[1] s[0] BPN gate_nand_x1
xBP1 VDD BPN BP VSS gate_inv_x1
xBN1 VDD BNN BN VSS gate_inv_x1
xNBN VDD VSS sn[0] s[1] BNN gate_nand_x1
xNRST VDD VSS sn[1] s[0] RSTN gate_nand_x1
xIRST VDD RSTN RST VSS gate_inv_x1
xISAM VDD SAMN SAM VSS gate_inv_x1
xNSAM VDD VSS sn[0] sn[1] SAMN gate_nand_x1
xS0 VDD s[0] sn[0] VSS gate_inv_x1
xS1 VDD s[1] sn[1] VSS gate_inv_x1
.ends

* expanding   symbol:  designs/sar_adc/dac/dac_sw_4state_B/xschem/dac_sw_4state_B.sym # of pins=8
** sym_path: /foss/designs/Chipathon-2026-OnChipSAR/designs/sar_adc/dac/dac_sw_4state_B/xschem/dac_sw_4state_B.sym
** sch_path: /foss/designs/Chipathon-2026-OnChipSAR/designs/sar_adc/dac/dac_sw_4state_B/xschem/dac_sw_4state_B.sch
.subckt dac_sw_4state_B VDD s[1] s[0] VSS CI VSAM VBP VBN VRST
*.PININFO VRST:I CI:B VSAM:I VBP:I VBN:I s[1:0]:I VDD:B VSS:B
xBP VDD VSS BP VBP CI BPN dac_sw_1state_B
xBN VDD VSS BN VBN CI BNN dac_sw_1state_B
xRST VDD VSS RST VRST CI RSTN dac_sw_1state_B
xSAM VDD VSS SAM VSAM CI SAMN dac_sw_1state_B
xNBP VDD VSS s[1] s[0] BPN gate_nand_x1
xBP1 VDD BPN BP VSS gate_inv_x1
xBN1 VDD BNN BN VSS gate_inv_x1
xNBN VDD VSS sn[0] s[1] BNN gate_nand_x1
xNRST VDD VSS sn[1] s[0] RSTN gate_nand_x1
xIRST VDD RSTN RST VSS gate_inv_x1
xISAM VDD SAMN SAM VSS gate_inv_x1
xNSAM VDD VSS sn[0] sn[1] SAMN gate_nand_x1
xS0 VDD s[0] sn[0] VSS gate_inv_x1
xS1 VDD s[1] sn[1] VSS gate_inv_x1
.ends

* expanding   symbol:  designs/sar_adc/digital/gate_tg_x1/xschem/gate_tg_x1.sym # of pins=6
** sym_path: /foss/designs/Chipathon-2026-OnChipSAR/designs/sar_adc/digital/gate_tg_x1/xschem/gate_tg_x1.sym
** sch_path: /foss/designs/Chipathon-2026-OnChipSAR/designs/sar_adc/digital/gate_tg_x1/xschem/gate_tg_x1.sch
.subckt gate_tg_x1 CLK A VDD B CLKN VSS
*.PININFO VDD:B VSS:B CLK:I CLKN:I A:B B:B
M1 A CLK B VSS nfet_03v3 L=0.28u W=0.5u nf=1
M2 A CLKN B VDD pfet_03v3 L=0.28u W=0.5u nf=1
.ends

* expanding   symbol:  designs/sar_adc/digital/gate_inv_x1/xschem/gate_inv_x1.sym # of pins=6
** sym_path: /foss/designs/Chipathon-2026-OnChipSAR/designs/sar_adc/digital/gate_inv_x1/xschem/gate_inv_x1.sym
** sch_path: /foss/designs/Chipathon-2026-OnChipSAR/designs/sar_adc/digital/gate_inv_x1/xschem/gate_inv_x1.sch
.subckt gate_inv_x1 VDD in out VSS
*.PININFO out:O in:B VDD:B VSS:B
M1 out in VSS VSS nfet_03v3 L=0.28u W=0.5u nf=1
M2 out in VDD VDD pfet_03v3 L=0.28u W=0.5u nf=1
.ends

* expanding   symbol:  designs/sar_adc/digital/gate_nand_x1/xschem/gate_nand_x1.sym # of pins=5
** sym_path: /foss/designs/Chipathon-2026-OnChipSAR/designs/sar_adc/digital/gate_nand_x1/xschem/gate_nand_x1.sym
** sch_path: /foss/designs/Chipathon-2026-OnChipSAR/designs/sar_adc/digital/gate_nand_x1/xschem/gate_nand_x1.sch
.subckt gate_nand_x1 VDD VSS A B out
*.PININFO A:B B:B out:B VDD:B VSS:B
M5 out A VDD VDD pfet_03v3 L=0.28u W=0.5u nf=1
M6 out A net1 VSS nfet_03v3 L=0.28u W=0.5u nf=1
M7 out B VDD VDD pfet_03v3 L=0.28u W=0.5u nf=1
M8 net1 B VSS VSS nfet_03v3 L=0.28u W=0.5u nf=1
.ends

* expanding   symbol:  designs/sar_adc/digital/gate_delay_edge/xschem/gate_delay_edge.sym # of pins=4
** sym_path: /foss/designs/Chipathon-2026-OnChipSAR/designs/sar_adc/digital/gate_delay_edge/xschem/gate_delay_edge.sym
** sch_path: /foss/designs/Chipathon-2026-OnChipSAR/designs/sar_adc/digital/gate_delay_edge/xschem/gate_delay_edge.sch
.subckt gate_delay_edge VDD IN OUT VSS
*.PININFO VDD:B VSS:B IN:I OUT:B
xINV0 VDD P0 IN VSS gate_inv_edge
xINV1 VDD P1 P0 VSS gate_inv_edge
xINV2 VDD P2 P1 VSS gate_inv_edge
xINV3 VDD P3 P2 VSS gate_inv_edge
xINV4 VDD OUT P3 VSS gate_inv_edge
.ends

* expanding   symbol:  designs/sar_adc/dac/dac_sw_1state_A/xschem/dac_sw_1state_A.sym # of pins=6
** sym_path: /foss/designs/Chipathon-2026-OnChipSAR/designs/sar_adc/dac/dac_sw_1state_A/xschem/dac_sw_1state_A.sym
** sch_path: /foss/designs/Chipathon-2026-OnChipSAR/designs/sar_adc/dac/dac_sw_1state_A/xschem/dac_sw_1state_A.sch
.subckt dac_sw_1state_A VDD VSS CLK VIN VOUT CLKN
*.PININFO VIN:B VOUT:B CLK:B CLKN:B VSS:B VDD:B
MSN VOUT CLK VIN VSS nfet_03v3 L=0.28u W=0.5u nf=1 m=4
MSP VIN CLKN VOUT VDD pfet_03v3 L=0.28u W=0.5u nf=1 m=4
.ends

* expanding   symbol:  designs/sar_adc/dac/dac_sw_1state_B/xschem/dac_sw_1state_B.sym # of pins=6
** sym_path: /foss/designs/Chipathon-2026-OnChipSAR/designs/sar_adc/dac/dac_sw_1state_B/xschem/dac_sw_1state_B.sym
** sch_path: /foss/designs/Chipathon-2026-OnChipSAR/designs/sar_adc/dac/dac_sw_1state_B/xschem/dac_sw_1state_B.sch
.subckt dac_sw_1state_B VDD VSS CLK VIN VOUT CLKN
*.PININFO VIN:B VOUT:B CLK:B CLKN:B VSS:B VDD:B
MSN VOUT CLK VIN VSS nfet_03v3 L=0.28u W=0.5u nf=1 m=10
MSP VIN CLKN VOUT VDD pfet_03v3 L=0.28u W=0.5u nf=1 m=10
.ends

* expanding   symbol:  designs/sar_adc/digital/gate_inv_edge/xschem/gate_inv_edge.sym # of pins=4
** sym_path: /foss/designs/Chipathon-2026-OnChipSAR/designs/sar_adc/digital/gate_inv_edge/xschem/gate_inv_edge.sym
** sch_path: /foss/designs/Chipathon-2026-OnChipSAR/designs/sar_adc/digital/gate_inv_edge/xschem/gate_inv_edge.sch
.subckt gate_inv_edge VDD B A VSS
*.PININFO B:O A:I VDD:B VSS:B
MN B A VSS VSS nfet_03v3 L=0.6u W=3u nf=1
MP B A VDD VDD pfet_03v3 L=0.60u W=3u nf=1 m=2
.ends
