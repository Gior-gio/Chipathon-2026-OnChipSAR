** sch_path: /foss/designs/Chipathon-2026-OnChipSAR/designs/sar_adc/top/comp_and_samp/xschem/comp_and_samp.sch
.subckt comp_and_samp VIN VY VX SAMP COMP CLK VSS VDD VRN
*.PININFO VIN:I VY:B VX:B SAMP:I COMP:B CLK:I VSS:B VDD:B VRN:I
xSHP VDD VSS SAMP VIN VX bootstrapped
xSHN VDD VSS SAMP VRN VY bootstrapped
xCOMP VDD CLK COMPN COMP VY VX VSS strongARM
* noconn COMPN
.ends

* expanding   symbol:  designs/sar_adc/samplehold/bootstrapped/xschem/bootstrapped.sym # of pins=5
** sym_path: /foss/designs/Chipathon-2026-OnChipSAR/designs/sar_adc/samplehold/bootstrapped/xschem/bootstrapped.sym
** sch_path: /foss/designs/Chipathon-2026-OnChipSAR/designs/sar_adc/samplehold/bootstrapped/xschem/bootstrapped.sch
.subckt bootstrapped VDD VSS CLK VIN VOUT
*.PININFO CLK:B VSS:B VDD:B VOUT:B VIN:B
XBS_SW_N7 net1 CLKN VSS VSS nfet_03v3 L=0.28u W=0.5u nf=1 m=2
XBS_SW_N3 cc VX Vcc VSS nfet_03v3 L=0.28u W=0.5u nf=1
XBS_SW_P3 VX cc Vc Vc pfet_03v3 L=0.28u W=1u nf=1
XBS_SW_N6 VX VDD net1 VSS nfet_03v3 L=0.28u W=0.5u nf=1 m=2
XBS_SW_P1 Vc VX VDD Vc pfet_03v3 L=0.28u W=1u nf=1
XBS_SW_N1 VOUT VX VIN VSS nfet_03v3 L=0.28u W=1.5u nf=1
XBS_SW_N2 VIN VX Vcc VSS nfet_03v3 L=0.28u W=0.5u nf=1
XBS_SW_N5 Vcc CLKN VSS VSS nfet_03v3 L=0.28u W=0.5u nf=1
XBS_SW_N4 cc CLK Vcc VSS nfet_03v3 L=0.28u W=0.5u nf=1
XBS_SW_P2 cc CLK VDD VDD pfet_03v3 L=0.28u W=0.5u nf=1 m=2
XCAP_BOOT Vc Vcc cap_mim_2f0fF c_width=11e-6 c_length=9.1e-6
M1 CLKN CLK VSS VSS nfet_03v3 L=0.28u W=0.5u nf=1
M2 CLKN CLK VDD VDD pfet_03v3 L=0.28u W=0.5u nf=1 m=2
.ends

* expanding   symbol:  designs/sar_adc/comparator/StrongARM/xschem/strongARM.sym # of pins=7
** sym_path: /foss/designs/Chipathon-2026-OnChipSAR/designs/sar_adc/comparator/StrongARM/xschem/strongARM.sym
** sch_path: /foss/designs/Chipathon-2026-OnChipSAR/designs/sar_adc/comparator/StrongARM/xschem/strongARM.sch
.subckt strongARM VDD CLK ON OP VIN VIP VSS
*.PININFO VSS:B VDD:B VIN:B VIP:B OP:B CLK:B ON:B
MTAIL NT CLKK VDD VDD pfet_03v3 L=0.5u W=0.5u nf=1 m=6
M2 AN CLKK VSS VSS nfet_03v3 L=0.5u W=0.5u nf=1 m=2
M3 AP VIP NT VDD pfet_03v3 L=0.5u W=0.5u nf=1 m=4
M4 AN VIN NT VDD pfet_03v3 L=0.5u W=0.5u nf=1 m=4
M5 AP CLKK VSS VSS nfet_03v3 L=0.5u W=0.5u nf=1 m=2
M6 ONN OPP VDD VDD pfet_03v3 L=0.5u W=0.5u nf=1 m=2
M7 OPP ONN VDD VDD pfet_03v3 L=0.5u W=0.5u nf=1 m=2
M8 ONN OPP CN VSS nfet_03v3 L=0.5u W=0.5u nf=1 m=2
M9 OPP ONN CP VSS nfet_03v3 L=0.5u W=0.5u nf=1 m=2
M10 CN AN VSS VSS nfet_03v3 L=0.5u W=0.5u nf=1 m=4
M11 CP AP VSS VSS nfet_03v3 L=0.5u W=0.5u nf=1 m=4
M12 ONN AN VDD VDD pfet_03v3 L=0.5u W=0.5u nf=1 m=2
M13 OPP AP VDD VDD pfet_03v3 L=0.5u W=0.5u nf=1 m=2
M14 CN AN VDD VDD pfet_03v3 L=0.5u W=0.5u nf=1 m=2
M15 CP AP VDD VDD pfet_03v3 L=0.5u W=0.5u nf=1 m=2
x1 VDD CLK CLKN VSS gate_inv_x2
x2 VDD CLKN CLKK VSS gate_inv_x2
x3 VDD ONN ON VSS gate_inv_x2
x4 VDD OPP OP VSS gate_inv_x2
.ends

* expanding   symbol:  designs/sar_adc/digital/gate_inv_x2/xschem/gate_inv_x2.sym # of pins=6
** sym_path: /foss/designs/Chipathon-2026-OnChipSAR/designs/sar_adc/digital/gate_inv_x2/xschem/gate_inv_x2.sym
** sch_path: /foss/designs/Chipathon-2026-OnChipSAR/designs/sar_adc/digital/gate_inv_x2/xschem/gate_inv_x2.sch
.subckt gate_inv_x2 VDD in out VSS
*.PININFO out:O in:B VDD:B VSS:B
M1 out in VSS VSS nfet_03v3 L=0.28u W=0.5u nf=1
M2 out in VDD VDD pfet_03v3 L=0.28u W=0.5u nf=1 m=2
.ends
