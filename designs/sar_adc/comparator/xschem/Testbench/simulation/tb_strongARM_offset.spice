** sch_path: /foss/designs/Chipathon-2026-OnChipSAR/designs/sar_adc/comparator/Testbench/tb_strongARM_offset.sch
**.subckt tb_strongARM_offset
V1 VDD GND 3.3
V2 VIP VIN pwl(0 {-offset_resolution} {num_cycles*T_clk} {offset_resolution})
V3 CLK GND pulse(3.3 0 1n 100p 100p {T_clk/2}) {T_clk})
V4 VIN GND {vcm}
x1 VDD CLK On Op VIN VIP GND strongARM
x2[9] VDD Op OPP GND inv
x2[8] VDD Op OPP GND inv
x2[7] VDD Op OPP GND inv
x2[6] VDD Op OPP GND inv
x2[5] VDD Op OPP GND inv
x2[4] VDD Op OPP GND inv
x2[3] VDD Op OPP GND inv
x2[2] VDD Op OPP GND inv
x2[1] VDD Op OPP GND inv
x2[0] VDD Op OPP GND inv
x1[9] VDD On ONN GND inv
x1[8] VDD On ONN GND inv
x1[7] VDD On ONN GND inv
x1[6] VDD On ONN GND inv
x1[5] VDD On ONN GND inv
x1[4] VDD On ONN GND inv
x1[3] VDD On ONN GND inv
x1[2] VDD On ONN GND inv
x1[1] VDD On ONN GND inv
x1[0] VDD On ONN GND inv
* noconn ONN
* noconn OPP
**** begin user architecture code

.param offset_resolution = 20e-3
.param vcm = 1.65
.param num_cycles = 16
.param frec_clk = 100e+6
.param T_clk = {1/frec_clk}

.include /foss/pdks/gf180mcuD/libs.tech/ngspice/design.ngspice
.lib '/foss/pdks/gf180mcuD/libs.tech/ngspice/sm141064.ngspice' typical
.tran 25p {num_cycles*T_clk}

.measure tran tpd_ON
+ TRIG v(CLK) VAL={vcm} RISE=1 TD=5n
+ TARG v(Op)      VAL={vcm} FALL=1

.measure tran VVIP_cross FIND v(VIP) WHEN v(On)=1.65 FALL=1
.measure tran Ofset param='VVIP_cross - vcm'

.measure tran I_avg AVG i(V1) FROM={1 * T_clk} TO={num_cycles*T_clk}
.measure tran p_avg PARAM = '3.3*abs(I_avg)'

.end

**** end user architecture code
**.ends

* expanding   symbol:  Chipathon-2026-OnChipSAR/designs/sar_adc/comparator/StrongARM/strongARM.sym # of pins=7
** sym_path: /foss/designs/Chipathon-2026-OnChipSAR/designs/sar_adc/comparator/StrongARM/strongARM.sym
** sch_path: /foss/designs/Chipathon-2026-OnChipSAR/designs/sar_adc/comparator/StrongARM/strongARM.sch
.subckt strongARM VDD CLK ON OP VIN VIP VSS
*.iopin VSS
*.iopin VDD
*.iopin VIN
*.iopin VIP
*.iopin OP
*.iopin CLK
*.iopin ON
Xq net5 CLKK VDD VDD pfet_03v3 L=0.28u W=10u nf=1 ad='int((nf+1)/2) * W/nf * 0.18u' as='int((nf+2)/2) * W/nf * 0.18u' pd='2*int((nf+1)/2) * (W/nf + 0.18u)'
+ ps='2*int((nf+2)/2) * (W/nf + 0.18u)' nrd='0.18u / W' nrs='0.18u / W' sa=0 sb=0 sd=0 m=1
XM2 AN CLKK VSS VSS nfet_03v3 L=0.28u W=0.22u nf=1 ad='int((nf+1)/2) * W/nf * 0.18u' as='int((nf+2)/2) * W/nf * 0.18u' pd='2*int((nf+1)/2) * (W/nf + 0.18u)'
+ ps='2*int((nf+2)/2) * (W/nf + 0.18u)' nrd='0.18u / W' nrs='0.18u / W' sa=0 sb=0 sd=0 m=1
XM3 AP VIP net5 VDD pfet_03v3 L=2u W=8u nf=1 ad='int((nf+1)/2) * W/nf * 0.18u' as='int((nf+2)/2) * W/nf * 0.18u' pd='2*int((nf+1)/2) * (W/nf + 0.18u)'
+ ps='2*int((nf+2)/2) * (W/nf + 0.18u)' nrd='0.18u / W' nrs='0.18u / W' sa=0 sb=0 sd=0 m=1
XM4 AN VIN net5 VDD pfet_03v3 L=2u W=8u nf=1 ad='int((nf+1)/2) * W/nf * 0.18u' as='int((nf+2)/2) * W/nf * 0.18u' pd='2*int((nf+1)/2) * (W/nf + 0.18u)'
+ ps='2*int((nf+2)/2) * (W/nf + 0.18u)' nrd='0.18u / W' nrs='0.18u / W' sa=0 sb=0 sd=0 m=1
XM5 AP CLKK VSS VSS nfet_03v3 L=0.28u W=0.22u nf=1 ad='int((nf+1)/2) * W/nf * 0.18u' as='int((nf+2)/2) * W/nf * 0.18u' pd='2*int((nf+1)/2) * (W/nf + 0.18u)'
+ ps='2*int((nf+2)/2) * (W/nf + 0.18u)' nrd='0.18u / W' nrs='0.18u / W' sa=0 sb=0 sd=0 m=1
XM6 net3 net4 VDD VDD pfet_03v3 L=0.28u W=0.22u nf=1 ad='int((nf+1)/2) * W/nf * 0.18u' as='int((nf+2)/2) * W/nf * 0.18u' pd='2*int((nf+1)/2) * (W/nf + 0.18u)'
+ ps='2*int((nf+2)/2) * (W/nf + 0.18u)' nrd='0.18u / W' nrs='0.18u / W' sa=0 sb=0 sd=0 m=1
XM7 net4 net3 VDD VDD pfet_03v3 L=0.28u W=0.22u nf=1 ad='int((nf+1)/2) * W/nf * 0.18u' as='int((nf+2)/2) * W/nf * 0.18u' pd='2*int((nf+1)/2) * (W/nf + 0.18u)'
+ ps='2*int((nf+2)/2) * (W/nf + 0.18u)' nrd='0.18u / W' nrs='0.18u / W' sa=0 sb=0 sd=0 m=1
XM8 net3 net4 net1 VSS nfet_03v3 L=0.28u W=0.22u nf=1 ad='int((nf+1)/2) * W/nf * 0.18u' as='int((nf+2)/2) * W/nf * 0.18u' pd='2*int((nf+1)/2) * (W/nf + 0.18u)'
+ ps='2*int((nf+2)/2) * (W/nf + 0.18u)' nrd='0.18u / W' nrs='0.18u / W' sa=0 sb=0 sd=0 m=1
XM9 net4 net3 net2 VSS nfet_03v3 L=0.28u W=0.22u nf=1 ad='int((nf+1)/2) * W/nf * 0.18u' as='int((nf+2)/2) * W/nf * 0.18u' pd='2*int((nf+1)/2) * (W/nf + 0.18u)'
+ ps='2*int((nf+2)/2) * (W/nf + 0.18u)' nrd='0.18u / W' nrs='0.18u / W' sa=0 sb=0 sd=0 m=1
XM10 net1 AN VSS VSS nfet_03v3 L=0.28u W=1u nf=1 ad='int((nf+1)/2) * W/nf * 0.18u' as='int((nf+2)/2) * W/nf * 0.18u' pd='2*int((nf+1)/2) * (W/nf + 0.18u)'
+ ps='2*int((nf+2)/2) * (W/nf + 0.18u)' nrd='0.18u / W' nrs='0.18u / W' sa=0 sb=0 sd=0 m=1
XM11 net2 AP VSS VSS nfet_03v3 L=0.28u W=1u nf=1 ad='int((nf+1)/2) * W/nf * 0.18u' as='int((nf+2)/2) * W/nf * 0.18u' pd='2*int((nf+1)/2) * (W/nf + 0.18u)'
+ ps='2*int((nf+2)/2) * (W/nf + 0.18u)' nrd='0.18u / W' nrs='0.18u / W' sa=0 sb=0 sd=0 m=1
XM12 net3 AN VDD VDD pfet_03v3 L=0.28u W=0.22u nf=1 ad='int((nf+1)/2) * W/nf * 0.18u' as='int((nf+2)/2) * W/nf * 0.18u' pd='2*int((nf+1)/2) * (W/nf + 0.18u)'
+ ps='2*int((nf+2)/2) * (W/nf + 0.18u)' nrd='0.18u / W' nrs='0.18u / W' sa=0 sb=0 sd=0 m=1
XM13 net4 AP VDD VDD pfet_03v3 L=0.28u W=0.22u nf=1 ad='int((nf+1)/2) * W/nf * 0.18u' as='int((nf+2)/2) * W/nf * 0.18u' pd='2*int((nf+1)/2) * (W/nf + 0.18u)'
+ ps='2*int((nf+2)/2) * (W/nf + 0.18u)' nrd='0.18u / W' nrs='0.18u / W' sa=0 sb=0 sd=0 m=1
XM14 net1 AN VDD VDD pfet_03v3 L=0.28u W=0.22u nf=1 ad='int((nf+1)/2) * W/nf * 0.18u' as='int((nf+2)/2) * W/nf * 0.18u' pd='2*int((nf+1)/2) * (W/nf + 0.18u)'
+ ps='2*int((nf+2)/2) * (W/nf + 0.18u)' nrd='0.18u / W' nrs='0.18u / W' sa=0 sb=0 sd=0 m=1
XM15 net2 AP VDD VDD pfet_03v3 L=0.28u W=0.22u nf=1 ad='int((nf+1)/2) * W/nf * 0.18u' as='int((nf+2)/2) * W/nf * 0.18u' pd='2*int((nf+1)/2) * (W/nf + 0.18u)'
+ ps='2*int((nf+2)/2) * (W/nf + 0.18u)' nrd='0.18u / W' nrs='0.18u / W' sa=0 sb=0 sd=0 m=1
C1 AN VSS 10f m=1
C2 AP VSS 10f m=1
x1 VDD net4 net6 VSS inv
x2 VDD net3 net7 VSS inv
x3 VDD net7 ON VSS inv
x4 VDD net6 OP VSS inv
x5 VDD CLK CLKK VSS inv
.ends

* expanding   symbol:  Chipathon-2026-OnChipSAR/designs/sar_adc/comparator/Inverter/inv.sym # of pins=4
** sym_path: /foss/designs/Chipathon-2026-OnChipSAR/designs/sar_adc/comparator/Inverter/inv.sym
** sch_path: /foss/designs/Chipathon-2026-OnChipSAR/designs/sar_adc/comparator/Inverter/inv.sch
.subckt inv vdd vi vo vss
*.iopin vdd
*.iopin vss
*.ipin vi
*.opin vo
XM1 vo vi vss vss nfet_03v3 L=0.28u W=0.22u nf=1 ad='int((nf+1)/2) * W/nf * 0.18u' as='int((nf+2)/2) * W/nf * 0.18u' pd='2*int((nf+1)/2) * (W/nf + 0.18u)'
+ ps='2*int((nf+2)/2) * (W/nf + 0.18u)' nrd='0.18u / W' nrs='0.18u / W' sa=0 sb=0 sd=0 m=1
XM2 vo vi vdd vdd pfet_03v3 L=0.28u W=0.22u nf=1 ad='int((nf+1)/2) * W/nf * 0.18u' as='int((nf+2)/2) * W/nf * 0.18u' pd='2*int((nf+1)/2) * (W/nf + 0.18u)'
+ ps='2*int((nf+2)/2) * (W/nf + 0.18u)' nrd='0.18u / W' nrs='0.18u / W' sa=0 sb=0 sd=0 m=1
.ends

.GLOBAL GND
.end
