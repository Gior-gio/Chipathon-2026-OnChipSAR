* NGSPICE file created from strongARM.ext - technology: gf180mcuD

.subckt strongARM VDD CLK ON OP VIN VIP VSS
X0 ONN AN VDD w_8272_n13024# pfet_03v3 ad=0.175p pd=1.2u as=0.175p ps=1.2u w=0.5u l=0.5u
X1 VDD ONN OPP w_8272_n13024# pfet_03v3 ad=0.175p pd=1.2u as=0.175p ps=1.2u w=0.5u l=0.5u
X2 ONN OPP VDD w_8272_n13024# pfet_03v3 ad=0.175p pd=1.2u as=0.175p ps=1.2u w=0.5u l=0.5u
X3 a_9960_n15971# CLK CLKN w_8716_n16314# pfet_03v3 ad=0.13p pd=1.02u as=0.305p ps=2.22u w=0.5u l=0.28u
X4 VDD AP OPP w_8272_n13024# pfet_03v3 ad=0.175p pd=1.2u as=0.175p ps=1.2u w=0.5u l=0.5u
X5 CP AP VDD w_8272_n13024# pfet_03v3 ad=0.175p pd=1.2u as=0.175p ps=1.2u w=0.5u l=0.5u
X6 CN AN VSS a_8316_n14306# nfet_03v3 ad=0.175p pd=1.2u as=0.31p ps=2.24u w=0.5u l=0.5u
X7 VSS CLKK AN a_8316_n14306# nfet_03v3 ad=0.305p pd=2.22u as=0.2p ps=1.3u w=0.5u l=0.5u
X8 CP AP VSS a_8316_n14306# nfet_03v3 ad=0.175p pd=1.2u as=0.175p ps=1.2u w=0.5u l=0.5u
X9 VSS CLKK AP a_8316_n14306# nfet_03v3 ad=0.2p pd=1.3u as=0.2p ps=1.3u w=0.5u l=0.5u
X10 ON ONN VDD w_8272_n13024# pfet_03v3 ad=0.325p pd=2.3u as=0.2p ps=1.3u w=0.5u l=0.28u
X11 ONN OPP CN a_8316_n14306# nfet_03v3 ad=0.175p pd=1.2u as=0.175p ps=1.2u w=0.5u l=0.5u
X12 CP ONN OPP a_8316_n14306# nfet_03v3 ad=0.175p pd=1.2u as=0.175p ps=1.2u w=0.5u l=0.5u
X13 NT VIP AP w_8716_n16314# pfet_03v3 ad=0.175p pd=1.2u as=0.175p ps=1.2u w=0.5u l=0.5u
X14 NT CLKK VDD w_8716_n16314# pfet_03v3 ad=0.175p pd=1.2u as=0.175p ps=1.2u w=0.5u l=0.5u
X15 VDD OPP OP w_8272_n13024# pfet_03v3 ad=0.2p pd=1.3u as=0.325p ps=2.3u w=0.5u l=0.28u
X16 VSS AN CN a_8316_n14306# nfet_03v3 ad=0.175p pd=1.2u as=0.175p ps=1.2u w=0.5u l=0.5u
X17 AN VIN NT w_8716_n16314# pfet_03v3 ad=0.175p pd=1.2u as=0.175p ps=1.2u w=0.5u l=0.5u
X18 NT VIN AN w_8716_n16314# pfet_03v3 ad=0.175p pd=1.2u as=0.175p ps=1.2u w=0.5u l=0.5u
X19 VDD CLKK NT w_8716_n16314# pfet_03v3 ad=0.175p pd=1.2u as=0.325p ps=2.3u w=0.5u l=0.5u
X20 NT CLKK VDD w_8716_n16314# pfet_03v3 ad=0.325p pd=2.3u as=0.175p ps=1.2u w=0.5u l=0.5u
X21 VSS AP CP a_8316_n14306# nfet_03v3 ad=0.32p pd=2.28u as=0.175p ps=1.2u w=0.5u l=0.5u
X22 CLKK CLKN a_9964_n16840# a_8316_n14306# nfet_03v3 ad=0.305p pd=2.22u as=0.13p ps=1.02u w=0.5u l=0.28u
X23 AP VIP NT w_8716_n16314# pfet_03v3 ad=0.175p pd=1.2u as=0.175p ps=1.2u w=0.5u l=0.5u
X24 VDD CLKK NT w_8716_n16314# pfet_03v3 ad=0.175p pd=1.2u as=0.175p ps=1.2u w=0.5u l=0.5u
X25 OPP ONN VDD w_8272_n13024# pfet_03v3 ad=0.175p pd=1.2u as=0.175p ps=1.2u w=0.5u l=0.5u
X26 CN AN VDD w_8272_n13024# pfet_03v3 ad=0.175p pd=1.2u as=0.325p ps=2.3u w=0.5u l=0.5u
X27 VDD AN ONN w_8272_n13024# pfet_03v3 ad=0.175p pd=1.2u as=0.175p ps=1.2u w=0.5u l=0.5u
X28 OPP AP VDD w_8272_n13024# pfet_03v3 ad=0.175p pd=1.2u as=0.175p ps=1.2u w=0.5u l=0.5u
X29 a_11402_n12540# AP CP w_8272_n13024# pfet_03v3 ad=0.325p pd=2.3u as=0.175p ps=1.2u w=0.5u l=0.5u
X30 CN AN a_8996_n13514# a_8316_n14306# nfet_03v3 ad=0.175p pd=1.2u as=0.175p ps=1.2u w=0.5u l=0.5u
X31 a_9964_n16840# CLK CLKN a_8316_n14306# nfet_03v3 ad=0.13p pd=1.02u as=0.305p ps=2.22u w=0.5u l=0.28u
X32 VDD OPP ONN w_8272_n13024# pfet_03v3 ad=0.175p pd=1.2u as=0.175p ps=1.2u w=0.5u l=0.5u
X33 OPP ONN CP a_8316_n14306# nfet_03v3 ad=0.175p pd=1.2u as=0.175p ps=1.2u w=0.5u l=0.5u
X34 ON ONN VSS a_8316_n14306# nfet_03v3 ad=0.305p pd=2.22u as=0.2p ps=1.3u w=0.5u l=0.28u
X35 CN OPP ONN a_8316_n14306# nfet_03v3 ad=0.175p pd=1.2u as=0.175p ps=1.2u w=0.5u l=0.5u
X36 a_8996_n13514# AN CN a_8316_n14306# nfet_03v3 ad=0.175p pd=1.2u as=0.175p ps=1.2u w=0.5u l=0.5u
X37 a_10916_n13514# AP CP a_8316_n14306# nfet_03v3 ad=0.175p pd=1.2u as=0.175p ps=1.2u w=0.5u l=0.5u
X38 AN CLKK VSS a_8316_n14306# nfet_03v3 ad=0.2p pd=1.3u as=0.2p ps=1.3u w=0.5u l=0.5u
X39 NT VIP AP w_8716_n16314# pfet_03v3 ad=0.175p pd=1.2u as=0.325p ps=2.3u w=0.5u l=0.5u
X40 AN VIN NT w_8716_n16314# pfet_03v3 ad=0.175p pd=1.2u as=0.175p ps=1.2u w=0.5u l=0.5u
X41 VDD CLKK NT w_8716_n16314# pfet_03v3 ad=0.175p pd=1.2u as=0.175p ps=1.2u w=0.5u l=0.5u
X42 VSS OPP OP a_8316_n14306# nfet_03v3 ad=0.2p pd=1.3u as=0.305p ps=2.22u w=0.5u l=0.28u
X43 CP AP a_10916_n13514# a_8316_n14306# nfet_03v3 ad=0.175p pd=1.2u as=0.175p ps=1.2u w=0.5u l=0.5u
X44 NT VIN AN w_8716_n16314# pfet_03v3 ad=0.175p pd=1.2u as=0.175p ps=1.2u w=0.5u l=0.5u
X45 AP VIP NT w_8716_n16314# pfet_03v3 ad=0.325p pd=2.3u as=0.175p ps=1.2u w=0.5u l=0.5u
X46 NT CLKK VDD w_8716_n16314# pfet_03v3 ad=0.175p pd=1.2u as=0.175p ps=1.2u w=0.5u l=0.5u
X47 CLKK CLKN a_9960_n15971# w_8716_n16314# pfet_03v3 ad=0.33p pd=2.32u as=0.13p ps=1.02u w=0.5u l=0.28u
X48 AP CLKK VSS a_8316_n14306# nfet_03v3 ad=0.2p pd=1.3u as=0.305p ps=2.22u w=0.5u l=0.5u
X49 VDD AN CN w_8272_n13024# pfet_03v3 ad=0.175p pd=1.2u as=0.175p ps=1.2u w=0.5u l=0.5u
C0 AN CN 0.4824f
C1 CP AN 0.0673f
C2 AP a_10916_n13514# 0.0027f
C3 a_10054_n16107# NT 0
C4 a_10054_n16107# VDD 0.01012f
C5 CN CLKK 0.10548f
C6 CP CLKK 0.03388f
C7 CLK NT 0
C8 AN ONN 0.57726f
C9 a_11402_n12540# VSS 0
C10 OP CN 0
C11 CLK VDD 0.11707f
C12 a_10054_n16107# w_8716_n16314# 0.13648f
C13 CLK a_9960_n15971# 0
C14 ONN CLKK 0.01083f
C15 CLK w_8716_n16314# 0.16836f
C16 CN NT 0
C17 CP NT 0
C18 OP ONN 0.05316f
C19 CN VDD 0.23562f
C20 CP VDD 0.21087f
C21 AN VIP 0.21538f
C22 ONN NT 0
C23 CN w_8716_n16314# 0
C24 CP w_8716_n16314# 0.00133f
C25 ONN VDD 0.9446f
C26 CLKK VIP 0.08104f
C27 CLKN a_10054_n16107# 0.02163f
C28 CLK CLKN 0.60855f
C29 ONN w_8716_n16314# 0.00179f
C30 VIP NT 0.37128f
C31 CN a_8996_n13514# 0.00387f
C32 VIP VDD 0.28951f
C33 CN w_8272_n13024# 0.06622f
C34 CP w_8272_n13024# 0.06632f
C35 CLK a_9964_n16840# 0
C36 VIP a_9960_n15971# 0
C37 VSS a_10054_n16107# 0
C38 VIP w_8716_n16314# 0.91298f
C39 AN CLKK 0.16161f
C40 ONN w_8272_n13024# 0.91149f
C41 CLK VSS 0.14629f
C42 VIN a_10054_n16107# 0
C43 OP AN 0
C44 OPP a_11402_n12540# 0
C45 CLK VIN 0
C46 AN NT 0.85955f
C47 AP a_10054_n16107# 0
C48 CN VSS 0.42091f
C49 CP VSS 0.4787f
C50 AN VDD 0.68198f
C51 CLKN VIP 0.02241f
C52 CLKK NT 0.46467f
C53 CLK AP 0
C54 CN VIN 0
C55 CP VIN 0
C56 CLKK VDD 1.1518f
C57 AN w_8716_n16314# 0.26599f
C58 ONN VSS 0.6484f
C59 CLKK a_9960_n15971# 0.00139f
C60 OP VDD 0.13756f
C61 CLKK w_8716_n16314# 1.53242f
C62 AP CN 0.03776f
C63 ONN VIN 0.00164f
C64 CP AP 0.46897f
C65 CP ON 0
C66 NT VDD 0.56615f
C67 AN a_8996_n13514# 0.00274f
C68 AP ONN 0.4348f
C69 VSS VIP 0.02878f
C70 VDD a_9960_n15971# 0.00896f
C71 NT w_8716_n16314# 0.5623f
C72 AN w_8272_n13024# 0.86873f
C73 AN CLKN 0
C74 ONN ON 0.29432f
C75 a_8996_n13514# CLKK 0
C76 VDD w_8716_n16314# 2.27414f
C77 VIN VIP 0.4006f
C78 CLKK w_8272_n13024# 0.00137f
C79 CLKN CLKK 0.31129f
C80 OP w_8272_n13024# 0.09311f
C81 AP VIP 0.16955f
C82 a_8996_n13514# VDD 0
C83 a_9964_n16840# CLKK 0
C84 CLKN NT 0.01128f
C85 w_8272_n13024# VDD 2.62252f
C86 AN VSS 1.18222f
C87 CLKN VDD 0.35456f
C88 OPP CN 0.5943f
C89 CP OPP 0.00887f
C90 CLKN a_9960_n15971# 0.00123f
C91 CLKK VSS 1.10026f
C92 AN VIN 1.04198f
C93 CLKN w_8716_n16314# 0.12464f
C94 OP VSS 0.23673f
C95 a_9964_n16840# VDD 0
C96 VIN CLKK 0.03476f
C97 OPP ONN 1.78349f
C98 CP a_10916_n13514# 0.00399f
C99 AN AP 0.39808f
C100 VSS NT 0.00771f
C101 AN ON 0.00121f
C102 VSS VDD 9.2697f
C103 AP CLKK 0.19005f
C104 ONN a_10916_n13514# 0
C105 VIN NT 0.41476f
C106 VSS a_9960_n15971# 0
C107 VIN VDD 0.13862f
C108 OPP VIP 0
C109 VSS w_8716_n16314# 0.14989f
C110 OP ON 0.00583f
C111 AP NT 0.20068f
C112 VIN w_8716_n16314# 0.87411f
C113 AP VDD 2.09571f
C114 a_9964_n16840# CLKN 0.00114f
C115 CP a_11402_n12540# 0.00186f
C116 ON VDD 0.13655f
C117 a_8996_n13514# VSS 0.01189f
C118 AP w_8716_n16314# 0.46356f
C119 VSS w_8272_n13024# 0.21597f
C120 CLKN VSS 0.43504f
C121 a_11402_n12540# ONN 0
C122 AN OPP 0.38707f
C123 CLKN VIN 0
C124 OPP CLKK 0.00648f
C125 a_9964_n16840# VSS 0.00987f
C126 AP w_8272_n13024# 0.86397f
C127 OP OPP 0.30101f
C128 CLKN AP 0
C129 ON w_8272_n13024# 0.0908f
C130 CLK a_10054_n16107# 0.0257f
C131 OPP VDD 0.98576f
C132 VIN VSS 0.01627f
C133 OPP w_8716_n16314# 0.00126f
C134 AP VSS 1.19045f
C135 a_10916_n13514# VDD 0
C136 VSS ON 0.23675f
C137 AP VIN 0.69642f
C138 OPP a_8996_n13514# 0
C139 CP CN 0.02455f
C140 OPP w_8272_n13024# 0.88591f
C141 AP ON 0
C142 VIP a_10054_n16107# 0.00132f
C143 ONN CN 0.02866f
C144 CP ONN 0.61249f
C145 a_11402_n12540# VDD 0.0128f
C146 CLK VIP 0.0044f
C147 OPP VSS 0.57451f
C148 CN VIP 0
C149 CP VIP 0
C150 OPP VIN 0.00319f
C151 AN a_10054_n16107# 0
C152 VSS a_10916_n13514# 0.01187f
C153 ONN VIP 0
C154 AP OPP 0.31462f
C155 CLK AN 0
C156 CLKK a_10054_n16107# 0.01601f
C157 OPP ON 0.06786f
C158 CLK CLKK 0.02553f
C159 CLKN a_8316_n14306# 0.38296f
C160 CLK a_8316_n14306# 0.18532f
C161 NT a_8316_n14306# 0.08055f
C162 VIN a_8316_n14306# 0.04249f
C163 VIP a_8316_n14306# 0.17274f
C164 CLKK a_8316_n14306# 1.41128f
C165 CP a_8316_n14306# 0.43749f
C166 CN a_8316_n14306# 0.42417f
C167 AP a_8316_n14306# 1.17218f
C168 AN a_8316_n14306# 1.13709f
C169 VDD a_8316_n14306# 7.42609f
C170 ON a_8316_n14306# 0.12106f
C171 VSS a_8316_n14306# 10.933f
C172 OP a_8316_n14306# 0.1237f
C173 ONN a_8316_n14306# 0.72815f
C174 OPP a_8316_n14306# 0.78073f
C175 a_10054_n16107# a_8316_n14306# 0.00559f
C176 w_8716_n16314# a_8316_n14306# 15.0698f
C177 w_8272_n13024# a_8316_n14306# 13.7937f
R_NWELL1 w_8272_n13024# VDD 0.001
R_NWELL2 w_8716_n16314# VDD 0.001
R_VSUBS a_8316_n14306# VSS 0.001
R_CLK_VDD a_9960_n15971# VDD 0.001
R_CLK_VSS a_9964_n16840# VSS 0.001
.ends
