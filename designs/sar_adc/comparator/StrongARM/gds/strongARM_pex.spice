* NGSPICE file created from strongARM.ext - technology: gf180mcuD

.subckt strongARM VDD CLK ON OP VIN VIP VSS
X0 OPP.t1 ONN.t9 VDD.t1 VDD.t0 pfet_03v3 ad=0.175p pd=1.2u as=0.175p ps=1.2u w=0.5u l=0.5u
X1 VDD.t51 AN.t10 ONN.t5 VDD.t50 pfet_03v3 ad=0.175p pd=1.2u as=0.175p ps=1.2u w=0.5u l=0.5u
X2 OPP.t5 AP.t13 VDD.t27 VDD.t26 pfet_03v3 ad=0.175p pd=1.2u as=0.175p ps=1.2u w=0.5u l=0.5u
X3 AN.t2 VIN.t3 NT.t4 VDD.t18 pfet_03v3 ad=0.175p pd=1.2u as=0.325p ps=2.3u w=0.5u l=0.5u
X4 NT.t3 VIP.t2 AP.t3 VDD.t33 pfet_03v3 ad=0.175p pd=1.2u as=0.175p ps=1.2u w=0.5u l=0.5u
X5 VDD.t37 CLK.t1 CLKN.t1 VDD.t36 pfet_03v3 ad=0.13p pd=1.02u as=0.305p ps=2.22u w=0.5u l=0.28u
X6 VDD.t43 OPP.t8 ONN.t1 VDD.t42 pfet_03v3 ad=0.175p pd=1.2u as=0.175p ps=1.2u w=0.5u l=0.5u
X7 AN.t4 VIN.t1 NT.t1 VDD.t20 pfet_03v3 ad=0.175p pd=1.2u as=0.175p ps=1.2u w=0.5u l=0.5u
X8 VDD.t25 AP.t10 CP.t2 VDD.t24 pfet_03v3 ad=0.325p pd=2.3u as=0.175p ps=1.2u w=0.5u l=0.5u
X9 NT.t11 VIP.t0 AP.t5 VDD.t35 pfet_03v3 ad=0.325p pd=2.3u as=0.175p ps=1.2u w=0.5u l=0.5u
X10 NT.t5 CLKK.t4 VDD.t13 VDD.t12 pfet_03v3 ad=0.175p pd=1.2u as=0.175p ps=1.2u w=0.5u l=0.5u
X11 ON.t0 ONN.t11 VSS.t1 VSS.t0 nfet_03v3 ad=0.305p pd=2.22u as=0.2p ps=1.3u w=0.5u l=0.28u
X12 CN.t4 AN.t9 VSS.t29 VSS.t28 nfet_03v3 ad=0.175p pd=1.2u as=0.31p ps=2.24u w=0.5u l=0.5u
X13 VDD.t7 CLKK.t7 NT.t8 VDD.t6 pfet_03v3 ad=0.175p pd=1.2u as=0.325p ps=2.3u w=0.5u l=0.5u
X14 NT.t2 CLKK.t2 VDD.t17 VDD.t16 pfet_03v3 ad=0.325p pd=2.3u as=0.175p ps=1.2u w=0.5u l=0.5u
X15 VDD.t41 OPP.t10 OP.t0 VDD.t40 pfet_03v3 ad=0.2p pd=1.3u as=0.325p ps=2.3u w=0.5u l=0.28u
X16 CP.t5 AP.t9 VSS.t13 VSS.t12 nfet_03v3 ad=0.175p pd=1.2u as=0.175p ps=1.2u w=0.5u l=0.5u
X17 CLKK.t0 CLKN.t2 VSS.t21 VSS.t20 nfet_03v3 ad=0.305p pd=2.22u as=0.13p ps=1.02u w=0.5u l=0.28u
X18 VSS.t25 OPP.t11 OP.t1 VSS.t24 nfet_03v3 ad=0.2p pd=1.3u as=0.305p ps=2.22u w=0.5u l=0.28u
X19 AP.t0 CLKK.t9 VSS.t9 VSS.t8 nfet_03v3 ad=0.2p pd=1.3u as=0.2p ps=1.3u w=0.5u l=0.5u
X20 VDD.t11 CLKK.t5 NT.t6 VDD.t10 pfet_03v3 ad=0.175p pd=1.2u as=0.175p ps=1.2u w=0.5u l=0.5u
X21 ONN.t3 OPP.t7 CN.t1 VSS.t26 nfet_03v3 ad=0.175p pd=1.2u as=0.175p ps=1.2u w=0.5u l=0.5u
X22 CP.t1 ONN.t6 OPP.t3 VSS.t3 nfet_03v3 ad=0.175p pd=1.2u as=0.175p ps=1.2u w=0.5u l=0.5u
X23 ONN.t4 AN.t11 VDD.t49 VDD.t48 pfet_03v3 ad=0.175p pd=1.2u as=0.175p ps=1.2u w=0.5u l=0.5u
X24 VDD.t5 ONN.t8 OPP.t0 VDD.t4 pfet_03v3 ad=0.175p pd=1.2u as=0.175p ps=1.2u w=0.5u l=0.5u
X25 VSS.t35 AN.t6 CN.t7 VSS.t34 nfet_03v3 ad=0.175p pd=1.2u as=0.175p ps=1.2u w=0.5u l=0.5u
X26 AN.t1 CLKK.t11 VSS.t5 VSS.t4 nfet_03v3 ad=0.2p pd=1.3u as=0.305p ps=2.22u w=0.5u l=0.5u
X27 VSS.t19 AP.t6 CP.t6 VSS.t18 nfet_03v3 ad=0.32p pd=2.28u as=0.175p ps=1.2u w=0.5u l=0.5u
X28 ONN.t2 OPP.t9 VDD.t39 VDD.t38 pfet_03v3 ad=0.175p pd=1.2u as=0.175p ps=1.2u w=0.5u l=0.5u
X29 VDD.t29 AP.t12 OPP.t4 VDD.t28 pfet_03v3 ad=0.175p pd=1.2u as=0.175p ps=1.2u w=0.5u l=0.5u
X30 VDD.t47 AN.t12 CN.t3 VDD.t46 pfet_03v3 ad=0.175p pd=1.2u as=0.175p ps=1.2u w=0.5u l=0.5u
X31 CP.t3 AP.t11 VDD.t23 VDD.t22 pfet_03v3 ad=0.175p pd=1.2u as=0.175p ps=1.2u w=0.5u l=0.5u
X32 AP.t2 VIP.t3 NT.t12 VDD.t32 pfet_03v3 ad=0.175p pd=1.2u as=0.175p ps=1.2u w=0.5u l=0.5u
X33 VSS.t23 CLK.t0 CLKN.t0 VSS.t22 nfet_03v3 ad=0.13p pd=1.02u as=0.305p ps=2.22u w=0.5u l=0.28u
X34 NT.t10 VIN.t2 AN.t3 VDD.t19 pfet_03v3 ad=0.175p pd=1.2u as=0.175p ps=1.2u w=0.5u l=0.5u
X35 AP.t4 VIP.t1 NT.t13 VDD.t34 pfet_03v3 ad=0.175p pd=1.2u as=0.175p ps=1.2u w=0.5u l=0.5u
X36 NT.t0 VIN.t0 AN.t5 VDD.t21 pfet_03v3 ad=0.175p pd=1.2u as=0.175p ps=1.2u w=0.5u l=0.5u
X37 VDD.t15 CLKK.t3 NT.t9 VDD.t14 pfet_03v3 ad=0.175p pd=1.2u as=0.175p ps=1.2u w=0.5u l=0.5u
X38 VSS.t7 CLKK.t10 AN.t0 VSS.t6 nfet_03v3 ad=0.2p pd=1.3u as=0.2p ps=1.3u w=0.5u l=0.5u
X39 VSS.t11 CLKK.t8 AP.t1 VSS.t10 nfet_03v3 ad=0.305p pd=2.22u as=0.2p ps=1.3u w=0.5u l=0.5u
X40 NT.t7 CLKK.t6 VDD.t9 VDD.t8 pfet_03v3 ad=0.175p pd=1.2u as=0.175p ps=1.2u w=0.5u l=0.5u
X41 CLKK.t1 CLKN.t3 VDD.t31 VDD.t30 pfet_03v3 ad=0.33p pd=2.32u as=0.13p ps=1.02u w=0.5u l=0.28u
X42 CN.t5 AN.t7 VSS.t33 VSS.t32 nfet_03v3 ad=0.175p pd=1.2u as=0.175p ps=1.2u w=0.5u l=0.5u
X43 OPP.t2 ONN.t7 CP.t0 VSS.t2 nfet_03v3 ad=0.175p pd=1.2u as=0.175p ps=1.2u w=0.5u l=0.5u
X44 CN.t0 OPP.t6 ONN.t0 VSS.t27 nfet_03v3 ad=0.175p pd=1.2u as=0.175p ps=1.2u w=0.5u l=0.5u
X45 VSS.t31 AN.t8 CN.t6 VSS.t30 nfet_03v3 ad=0.175p pd=1.2u as=0.175p ps=1.2u w=0.5u l=0.5u
X46 VSS.t15 AP.t8 CP.t4 VSS.t14 nfet_03v3 ad=0.175p pd=1.2u as=0.175p ps=1.2u w=0.5u l=0.5u
X47 CP.t7 AP.t7 VSS.t17 VSS.t16 nfet_03v3 ad=0.175p pd=1.2u as=0.175p ps=1.2u w=0.5u l=0.5u
X48 ON.t1 ONN.t10 VDD.t3 VDD.t2 pfet_03v3 ad=0.325p pd=2.3u as=0.2p ps=1.3u w=0.5u l=0.28u
X49 CN.t2 AN.t13 VDD.t45 VDD.t44 pfet_03v3 ad=0.175p pd=1.2u as=0.325p ps=2.3u w=0.5u l=0.5u
R0 CLKN.n5 CLKN.t3 25.9898
R1 CLKN CLKN.t2 25.9898
R2 CLKN.n1 CLKN.t0 11.3405
R3 CLKN.n3 CLKN.n2 9.4445
R4 CLKN.n0 CLKN.t1 8.8405
R5 CLKN.n2 CLKN.n1 5.1155
R6 CLKN.n2 CLKN.n0 5.11307
R7 CLKN.n3 CLKN 4.90175
R8 CLKN.n6 CLKN.n5 4.5005
R9 CLKN.n6 CLKN.n3 0.4055
R10 CLKN.n5 CLKN.n4 0.02525
R11 CLKN.n1 CLKN 0.00275
R12 CLKN CLKN.n6 0.001625
R13 CLKN.n0 CLKN 0.00159756
R14 CLK.n0 CLK.t0 25.9898
R15 CLK.n1 CLK.t1 25.9898
R16 CLK.n1 CLK.n0 9.83562
R17 CLK.n0 CLK 0.00275
R18 CLK CLK.n1 0.001625
R19 NT NT.t2 11.0816
R20 NT.n1 NT.t8 11.0805
R21 NT.n0 NT.t4 11.0805
R22 NT.n17 NT.t11 11.0805
R23 NT.n17 NT.n16 9.94679
R24 NT.n2 NT.n0 9.92279
R25 NT.n5 NT.n4 9.60479
R26 NT.n10 NT.n9 9.60479
R27 NT.n15 NT.n14 9.60479
R28 NT.n2 NT.n1 9.40663
R29 NT.n7 NT 9.40228
R30 NT.n12 NT 9.40228
R31 NT.n16 NT 9.40228
R32 NT NT.n6 5.20163
R33 NT NT.n11 5.20163
R34 NT.n4 NT.n3 5.2005
R35 NT.n9 NT.n8 5.2005
R36 NT.n14 NT.n13 5.2005
R37 NT.n3 NT.t1 4.9005
R38 NT.n3 NT.t10 4.9005
R39 NT.n6 NT.t6 4.9005
R40 NT.n6 NT.t7 4.9005
R41 NT.n8 NT.t12 4.9005
R42 NT.n8 NT.t0 4.9005
R43 NT.n11 NT.t9 4.9005
R44 NT.n11 NT.t5 4.9005
R45 NT.n13 NT.t13 4.9005
R46 NT.n13 NT.t3 4.9005
R47 NT.n5 NT.n2 0.3635
R48 NT.n15 NT.n12 0.3425
R49 NT.n10 NT.n7 0.3425
R50 NT.n16 NT.n15 0.3395
R51 NT.n12 NT.n10 0.3185
R52 NT.n7 NT.n5 0.3185
R53 NT.n0 NT 0.0185
R54 NT.n14 NT 0.01175
R55 NT.n4 NT 0.005
R56 NT.n9 NT 0.005
R57 NT NT.n17 0.003875
R58 NT.n1 NT 0.001625
R59 VIP.n0 VIP.t2 18.8158
R60 VIP VIP.t3 18.8135
R61 VIP VIP.t1 18.809
R62 VIP VIP.t0 18.8045
R63 VIP VIP.n2 9.31175
R64 VIP.n1 VIP 9.30275
R65 VIP.n2 VIP 9.00725
R66 VIP.n1 VIP.n0 9.0005
R67 VIP.n2 VIP.n1 0.3605
R68 VIP.n0 VIP 0.00725
R69 VIN.n1 VIN.t2 18.8158
R70 VIN.n4 VIN.t0 18.8158
R71 VIN.n0 VIN.t3 18.8045
R72 VIN VIN.t1 18.8045
R73 VIN.n2 VIN.n0 9.31475
R74 VIN.n4 VIN.n3 9.3005
R75 VIN.n3 VIN 9.01175
R76 VIN.n2 VIN.n1 9.0005
R77 VIN.n3 VIN.n2 0.3605
R78 VIN.n1 VIN 0.02975
R79 VIN VIN.n4 0.023
R80 VIN.n0 VIN 0.01175
R81 CLKK CLKK.t2 18.8045
R82 CLKK CLKK.t3 18.8045
R83 CLKK.n11 CLKK.t4 18.8045
R84 CLKK.n14 CLKK.t5 18.8045
R85 CLKK CLKK.t6 18.8045
R86 CLKK.n17 CLKK.t7 18.8045
R87 CLKK.n3 CLKK.t9 18.6585
R88 CLKK.n1 CLKK.t10 18.6585
R89 CLKK.n0 CLKK.t11 18.6585
R90 CLKK.n5 CLKK.t8 18.6585
R91 CLKK.n7 CLKK.n6 14.405
R92 CLKK.n9 CLKK.t0 11.3405
R93 CLKK.n2 CLKK.n0 9.3605
R94 CLKK.n17 CLKK.n16 9.33163
R95 CLKK.n7 CLKK 9.00163
R96 CLKK.n8 CLKK 9.00163
R97 CLKK.n15 CLKK.n14 9.00163
R98 CLKK.n16 CLKK 9.00163
R99 CLKK.n2 CLKK.n1 9.0005
R100 CLKK.n6 CLKK.n5 9.0005
R101 CLKK.n4 CLKK.n3 9.0005
R102 CLKK CLKK.t1 8.84162
R103 CLKK.n10 CLKK.n9 5.74255
R104 CLKK.n13 CLKK.n12 4.559
R105 CLKK.n10 CLKK 4.5005
R106 CLKK.n12 CLKK.n10 3.93933
R107 CLKK.n12 CLKK.n11 2.309
R108 CLKK.n4 CLKK.n2 0.3605
R109 CLKK.n6 CLKK.n4 0.3605
R110 CLKK.n16 CLKK.n15 0.3305
R111 CLKK.n15 CLKK.n13 0.3305
R112 CLKK.n8 CLKK.n7 0.3305
R113 CLKK.n13 CLKK.n8 0.29225
R114 CLKK.n1 CLKK 0.02525
R115 CLKK.n0 CLKK 0.023
R116 CLKK.n5 CLKK 0.023
R117 CLKK.n9 CLKK 0.0095
R118 CLKK.n11 CLKK 0.005
R119 CLKK.n3 CLKK 0.00275
R120 CLKK.n14 CLKK 0.001625
R121 CLKK CLKK.n17 0.001625
R122 CP.n5 CP.n2 10.4208
R123 CP.n5 CP.n4 9.67879
R124 CP.n4 CP.n3 6.3005
R125 CP CP.n7 6.3005
R126 CP.n2 CP.n1 6.3005
R127 CP.n6 CP 5.65443
R128 CP CP.n0 5.2005
R129 CP CP.n6 5.19768
R130 CP.n6 CP.n5 5.1845
R131 CP.n0 CP.t2 4.9005
R132 CP.n0 CP.t3 4.9005
R133 CP.n1 CP.t0 4.4105
R134 CP.n1 CP.t5 4.4105
R135 CP.n3 CP.t4 4.4105
R136 CP.n3 CP.t1 4.4105
R137 CP.n7 CP.t6 4.4105
R138 CP.n7 CP.t7 4.4105
R139 CP.n4 CP 0.00275
R140 CP.n2 CP 0.00275
R141 CN.n7 CN.n6 10.4109
R142 CN.n6 CN.n5 9.68193
R143 CN CN.n2 6.3005
R144 CN.n7 CN.n0 6.3005
R145 CN.n5 CN.n4 6.3005
R146 CN.n3 CN 5.65346
R147 CN CN.n1 5.2005
R148 CN.n3 CN 5.19543
R149 CN.n6 CN.n3 5.1875
R150 CN.n1 CN.t3 4.9005
R151 CN.n1 CN.t2 4.9005
R152 CN.n4 CN.t1 4.4105
R153 CN.n4 CN.t5 4.4105
R154 CN.n2 CN.t6 4.4105
R155 CN.n2 CN.t4 4.4105
R156 CN.n0 CN.t7 4.4105
R157 CN.n0 CN.t0 4.4105
R158 CN CN.n7 0.014
R159 CN.n5 CN 0.0095
R160 AP AP.t11 18.8045
R161 AP AP.t12 18.8045
R162 AP AP.t13 18.8045
R163 AP AP.t10 18.8045
R164 AP AP.t7 18.6585
R165 AP AP.t8 18.6585
R166 AP AP.t9 18.6585
R167 AP AP.t6 18.6585
R168 AP.n7 AP.n6 14.9009
R169 AP.n2 AP.n1 9.4385
R170 AP.n9 AP 9.37475
R171 AP.n10 AP 9.37175
R172 AP.n9 AP 9.014
R173 AP AP.n11 6.36807
R174 AP.n1 AP.n0 6.3005
R175 AP.n8 AP.n7 5.75729
R176 AP.n7 AP.n4 5.21086
R177 AP.n6 AP.n5 5.2005
R178 AP.n4 AP.n3 5.2005
R179 AP.n0 AP.t1 5.0405
R180 AP.n0 AP.t0 5.0405
R181 AP.n5 AP.t3 4.9005
R182 AP.n5 AP.t2 4.9005
R183 AP.n3 AP.t5 4.9005
R184 AP.n3 AP.t4 4.9005
R185 AP.n11 AP 4.51175
R186 AP.n11 AP.n10 4.5005
R187 AP.n8 AP.n2 0.806587
R188 AP.n10 AP.n9 0.2975
R189 AP.n2 AP 0.215717
R190 AP AP.n8 0.196152
R191 AP.n1 AP 0.01625
R192 AP.n6 AP 0.00760526
R193 AP.n4 AP 0.00523684
R194 AN AN.t13 18.8045
R195 AN AN.t12 18.8045
R196 AN AN.t11 18.8045
R197 AN AN.t10 18.8045
R198 AN AN.t8 18.6585
R199 AN AN.t9 18.6585
R200 AN.n9 AN.t7 18.6585
R201 AN AN.t6 18.6585
R202 AN.n7 AN.n6 14.9009
R203 AN.n2 AN.n1 9.4385
R204 AN AN.n12 9.37175
R205 AN.n11 AN 9.37175
R206 AN.n12 AN 9.01175
R207 AN.n10 AN 6.36712
R208 AN.n1 AN.n0 6.3005
R209 AN.n8 AN.n7 5.75729
R210 AN.n7 AN.n4 5.21086
R211 AN.n6 AN.n5 5.2005
R212 AN.n4 AN.n3 5.2005
R213 AN.n0 AN.t0 5.0405
R214 AN.n0 AN.t1 5.0405
R215 AN.n5 AN.t5 4.9005
R216 AN.n5 AN.t4 4.9005
R217 AN.n3 AN.t3 4.9005
R218 AN.n3 AN.t2 4.9005
R219 AN.n10 AN 4.51175
R220 AN.n11 AN.n10 4.5005
R221 AN.n8 AN.n2 0.814413
R222 AN.n12 AN.n11 0.3005
R223 AN.n2 AN 0.207891
R224 AN.n9 AN.n8 0.196152
R225 AN.n6 AN 0.0218158
R226 AN.n4 AN 0.00997368
R227 AN.n1 AN 0.0095
R228 AN AN.n9 0.00523684
R229 ON.n1 ON.t0 11.3405
R230 ON.n0 ON.t1 11.0805
R231 ON.n1 ON.n0 10.2248
R232 ON.n0 ON 0.0123421
R233 ON ON.n1 0.005
R234 OP.n0 OP.t1 11.3405
R235 OP OP.t0 11.1103
R236 OP.n0 OP 10.2095
R237 OP OP.n0 0.01175
R238 ONN ONN.t10 25.9898
R239 ONN.n6 ONN.t11 25.9898
R240 ONN ONN.t9 18.8045
R241 ONN ONN.t8 18.8045
R242 ONN.n10 ONN.t7 18.6585
R243 ONN ONN.t6 18.6585
R244 ONN.n8 ONN 13.8823
R245 ONN ONN.n11 13.8748
R246 ONN.n3 ONN.n2 10.1135
R247 ONN.n3 ONN 9.9215
R248 ONN.n5 ONN 9.63275
R249 ONN.n2 ONN.n1 6.3005
R250 ONN.n11 ONN.n9 5.7185
R251 ONN.n7 ONN.n6 5.23513
R252 ONN ONN.n4 5.2005
R253 ONN ONN.n0 5.2005
R254 ONN.n4 ONN.t1 4.9005
R255 ONN.n4 ONN.t2 4.9005
R256 ONN.n0 ONN.t5 4.9005
R257 ONN.n0 ONN.t4 4.9005
R258 ONN.n9 ONN.n8 4.88675
R259 ONN.n8 ONN 4.51175
R260 ONN.n11 ONN.n10 4.5005
R261 ONN.n7 ONN 4.5005
R262 ONN.n1 ONN.t0 4.4105
R263 ONN.n1 ONN.t3 4.4105
R264 ONN.n8 ONN.n7 0.882369
R265 ONN.n9 ONN.n5 0.4895
R266 ONN.n5 ONN.n3 0.3515
R267 ONN.n6 ONN 0.005
R268 ONN.n2 ONN 0.00275
R269 ONN.n10 ONN 0.00241489
R270 OPP.n3 OPP.t10 25.9898
R271 OPP.n2 OPP.t11 25.9898
R272 OPP OPP.t9 18.8045
R273 OPP OPP.t8 18.8045
R274 OPP OPP.t6 18.6585
R275 OPP OPP.t7 18.6585
R276 OPP.n5 OPP 13.8823
R277 OPP.n1 OPP 13.8552
R278 OPP.n11 OPP.n10 10.3205
R279 OPP OPP.n11 9.7385
R280 OPP.n8 OPP 9.4235
R281 OPP.n10 OPP.n9 6.3005
R282 OPP.n6 OPP.n1 5.9705
R283 OPP.n4 OPP.n2 5.23263
R284 OPP OPP.n7 5.2005
R285 OPP OPP.n0 5.2005
R286 OPP.n7 OPP.t0 4.9005
R287 OPP.n7 OPP.t1 4.9005
R288 OPP.n0 OPP.t4 4.9005
R289 OPP.n0 OPP.t5 4.9005
R290 OPP.n6 OPP.n5 4.67727
R291 OPP.n5 OPP 4.51175
R292 OPP.n1 OPP 4.50725
R293 OPP.n4 OPP.n3 4.5005
R294 OPP.n9 OPP.t3 4.4105
R295 OPP.n9 OPP.t2 4.4105
R296 OPP.n5 OPP.n4 0.885547
R297 OPP.n8 OPP.n6 0.5015
R298 OPP.n11 OPP.n8 0.3245
R299 OPP.n3 OPP 0.02975
R300 OPP.n2 OPP 0.005
R301 OPP.n10 OPP 0.00275
R302 VDD.t24 VDD.n42 257.533
R303 VDD.n44 VDD.t44 257.533
R304 VDD.t35 VDD.n3 223.456
R305 VDD.t18 VDD.n4 195.258
R306 VDD.t22 VDD.t24 184.049
R307 VDD.t28 VDD.t22 184.049
R308 VDD.t26 VDD.t28 184.049
R309 VDD.t4 VDD.t26 184.049
R310 VDD.t0 VDD.t4 184.049
R311 VDD.t38 VDD.t42 184.049
R312 VDD.t50 VDD.t38 184.049
R313 VDD.t48 VDD.t50 184.049
R314 VDD.t46 VDD.t48 184.049
R315 VDD.t44 VDD.t46 184.049
R316 VDD.n44 VDD.n18 150.851
R317 VDD.n44 VDD.n19 150.851
R318 VDD.n42 VDD.n19 150.851
R319 VDD.n42 VDD.n18 150.851
R320 VDD.n77 VDD.n3 143.71
R321 VDD.n77 VDD.n4 143.71
R322 VDD.n5 VDD.n3 137.69
R323 VDD.n5 VDD.n4 137.69
R324 VDD.t34 VDD.t35 120.847
R325 VDD.t33 VDD.t16 116.819
R326 VDD.t32 VDD.t14 116.819
R327 VDD.t10 VDD.t20 116.819
R328 VDD.t8 VDD.t19 116.819
R329 VDD.t6 VDD.t18 116.819
R330 VDD.n75 VDD.n3 87.8505
R331 VDD.n75 VDD.n4 87.8505
R332 VDD.t40 VDD.n43 84.3563
R333 VDD.n43 VDD.t2 81.2888
R334 VDD.n76 VDD.t36 61.4305
R335 VDD.t30 VDD.t12 23.1626
R336 VDD.n76 VDD.t30 19.1344
R337 VDD.n12 VDD.n11 18.4932
R338 VDD.n25 VDD.n24 18.3256
R339 VDD.n81 VDD.n0 18.2525
R340 VDD.n50 VDD.n13 18.097
R341 VDD VDD.n81 18.0425
R342 VDD.n12 VDD.n7 18.0041
R343 VDD.n80 VDD.n79 18.0014
R344 VDD.n17 VDD.n14 18.0014
R345 VDD.n23 VDD.n22 18.001
R346 VDD.n72 VDD.n71 13.5032
R347 VDD.n56 VDD.n55 13.5014
R348 VDD.t36 VDD.t21 13.0921
R349 VDD VDD.t25 11.0805
R350 VDD VDD.t45 11.0805
R351 VDD.t2 VDD.t0 10.7367
R352 VDD.n39 VDD.n15 9.31605
R353 VDD.n48 VDD.n47 9.0023
R354 VDD.n16 VDD 9.0015
R355 VDD.n28 VDD 9.0015
R356 VDD.n30 VDD 9.0015
R357 VDD.n32 VDD 9.0015
R358 VDD.n35 VDD.n34 9.0015
R359 VDD.n37 VDD 9.0015
R360 VDD.n61 VDD 9.0015
R361 VDD.n63 VDD 9.0015
R362 VDD.n65 VDD 9.0015
R363 VDD.n38 VDD 9.0015
R364 VDD.n59 VDD.n2 9.0005
R365 VDD.n66 VDD.n58 9.0005
R366 VDD.n47 VDD.n46 9.0005
R367 VDD.n40 VDD.n39 9.0005
R368 VDD.t42 VDD.t40 7.66921
R369 VDD.n21 VDD.t3 5.6005
R370 VDD.n21 VDD.t41 5.6005
R371 VDD.n22 VDD.n21 5.2015
R372 VDD VDD.n27 5.2005
R373 VDD VDD.n29 5.2005
R374 VDD VDD.n31 5.2005
R375 VDD.n34 VDD.n33 5.2005
R376 VDD VDD.n36 5.2005
R377 VDD VDD.n60 5.2005
R378 VDD VDD.n62 5.2005
R379 VDD VDD.n64 5.2005
R380 VDD VDD.n82 5.2005
R381 VDD.n27 VDD.t49 4.9005
R382 VDD.n27 VDD.t47 4.9005
R383 VDD.n29 VDD.t39 4.9005
R384 VDD.n29 VDD.t51 4.9005
R385 VDD.n31 VDD.t1 4.9005
R386 VDD.n31 VDD.t43 4.9005
R387 VDD.n33 VDD.t27 4.9005
R388 VDD.n33 VDD.t5 4.9005
R389 VDD.n36 VDD.t23 4.9005
R390 VDD.n36 VDD.t29 4.9005
R391 VDD.n60 VDD.t9 4.9005
R392 VDD.n60 VDD.t7 4.9005
R393 VDD.n62 VDD.t13 4.9005
R394 VDD.n62 VDD.t11 4.9005
R395 VDD.n64 VDD.t17 4.9005
R396 VDD.n64 VDD.t15 4.9005
R397 VDD.n59 VDD.n9 4.5014
R398 VDD.n67 VDD.n66 4.5014
R399 VDD.n55 VDD.n54 4.50101
R400 VDD.n71 VDD.n70 4.5005
R401 VDD.n69 VDD.n9 4.5005
R402 VDD.n68 VDD.n67 4.5005
R403 VDD.t16 VDD.t34 4.0287
R404 VDD.t14 VDD.t33 4.0287
R405 VDD.t12 VDD.t32 4.0287
R406 VDD.t21 VDD.t10 4.0287
R407 VDD.t20 VDD.t8 4.0287
R408 VDD.t19 VDD.t6 4.0287
R409 VDD.n82 VDD.t31 3.6405
R410 VDD.n82 VDD.t37 3.6405
R411 VDD.n40 VDD.n26 2.1165
R412 VDD.n25 VDD.n20 1.6435
R413 VDD.n20 VDD.n17 1.60115
R414 VDD.n26 VDD.n13 1.5985
R415 VDD.n78 VDD.n0 1.2475
R416 VDD.n11 VDD.n10 1.2475
R417 VDD.n10 VDD.n7 1.2455
R418 VDD.n79 VDD.n78 1.207
R419 VDD.n74 VDD.n6 1.2065
R420 VDD.n74 VDD.n73 1.2065
R421 VDD.n66 VDD.n65 1.1615
R422 VDD.n61 VDD.n59 1.0655
R423 VDD.n73 VDD.n7 0.7493
R424 VDD.n11 VDD.n6 0.7473
R425 VDD.n38 VDD.n37 0.6995
R426 VDD.n28 VDD.n16 0.6935
R427 VDD.n79 VDD.n2 0.6805
R428 VDD.n30 VDD.n28 0.6785
R429 VDD.n37 VDD.n35 0.6755
R430 VDD.n35 VDD.n32 0.6755
R431 VDD.n65 VDD.n63 0.6755
R432 VDD.n63 VDD.n61 0.6755
R433 VDD.n32 VDD.n30 0.6725
R434 VDD.n58 VDD.n0 0.6422
R435 VDD.n45 VDD.n44 0.6305
R436 VDD.n42 VDD.n41 0.6305
R437 VDD.n45 VDD.n17 0.535018
R438 VDD.n54 VDD.n53 0.511497
R439 VDD.n69 VDD.n68 0.5029
R440 VDD.n46 VDD.n13 0.500735
R441 VDD.n41 VDD.n25 0.4952
R442 VDD.n8 VDD.n4 0.39425
R443 VDD.n57 VDD.n3 0.39425
R444 VDD.n24 VDD.n14 0.320361
R445 VDD.n48 VDD.n15 0.314249
R446 VDD.n47 VDD.n16 0.2555
R447 VDD.n75 VDD.n74 0.2525
R448 VDD.n76 VDD.n75 0.2525
R449 VDD.n39 VDD.n38 0.2495
R450 VDD.n81 VDD.n80 0.235646
R451 VDD.n78 VDD.n77 0.233833
R452 VDD.n77 VDD.n76 0.233833
R453 VDD.n10 VDD.n5 0.233833
R454 VDD.n76 VDD.n5 0.233833
R455 VDD.n80 VDD.n1 0.204627
R456 VDD.n20 VDD.n18 0.1805
R457 VDD.n43 VDD.n18 0.1805
R458 VDD.n26 VDD.n19 0.1805
R459 VDD.n43 VDD.n19 0.1805
R460 VDD.n69 VDD.n1 0.1741
R461 VDD.n53 VDD.n52 0.173815
R462 VDD.n51 VDD.n12 0.173559
R463 VDD.n58 VDD.n57 0.1447
R464 VDD.n8 VDD.n2 0.1445
R465 VDD.n49 VDD.n14 0.106008
R466 VDD.n49 VDD.n48 0.0891988
R467 VDD.n67 VDD.n55 0.0850465
R468 VDD.n71 VDD.n9 0.0824
R469 VDD.n51 VDD.n50 0.0758092
R470 VDD.n23 VDD.n15 0.0557475
R471 VDD.n57 VDD.n56 0.0383
R472 VDD.n72 VDD.n8 0.0365
R473 VDD.n24 VDD.n23 0.0337673
R474 VDD.n46 VDD.n45 0.0311
R475 VDD.n41 VDD.n40 0.0311
R476 VDD.n52 VDD.n51 0.0278774
R477 VDD.n50 VDD.n49 0.0229733
R478 VDD.n68 VDD.n54 0.0188266
R479 VDD.n70 VDD.n69 0.0169
R480 VDD.n52 VDD.n1 0.0155959
R481 VDD.n70 VDD.n53 0.0145
R482 VDD.n22 VDD 0.0075
R483 VDD.n34 VDD 0.0065
R484 VDD.n73 VDD.n72 0.0032
R485 VDD.n56 VDD.n6 0.0014
R486 VSS.n65 VSS.n64 11307.5
R487 VSS.n22 VSS.n21 10558
R488 VSS.n25 VSS.n8 10050.6
R489 VSS.n24 VSS.n23 9646.16
R490 VSS.t20 VSS.n24 1653.58
R491 VSS.t24 VSS.n65 1445.8
R492 VSS.t22 VSS.n25 1408.61
R493 VSS.n21 VSS.t0 1380.64
R494 VSS.t18 VSS.t16 513.835
R495 VSS.t16 VSS.t14 513.835
R496 VSS.t14 VSS.t3 513.835
R497 VSS.t32 VSS.t26 513.835
R498 VSS.t30 VSS.t32 513.835
R499 VSS.t28 VSS.t30 513.835
R500 VSS.t27 VSS.t6 496.707
R501 VSS.t2 VSS.t8 488.142
R502 VSS.n66 VSS.t0 472.432
R503 VSS.t26 VSS.t4 453.887
R504 VSS.n29 VSS.t22 449.122
R505 VSS.t3 VSS.t10 445.324
R506 VSS.n66 VSS.t24 407.269
R507 VSS.n63 VSS.t12 278.327
R508 VSS.n22 VSS.t18 239.79
R509 VSS.t34 VSS.n63 235.507
R510 VSS.n29 VSS.t20 204.147
R511 VSS.n64 VSS.t28 171.279
R512 VSS.n62 VSS.n10 167.612
R513 VSS.n62 VSS.n11 167.612
R514 VSS.n10 VSS.n9 167.612
R515 VSS.n11 VSS.n9 167.612
R516 VSS.n64 VSS.n8 133.1
R517 VSS.n23 VSS.n22 125.001
R518 VSS.t10 VSS.t2 68.5117
R519 VSS.t4 VSS.t27 59.9478
R520 VSS.n28 VSS.n20 54.8338
R521 VSS.n30 VSS.n20 54.8338
R522 VSS.n30 VSS.n19 54.8338
R523 VSS.n28 VSS.n19 54.8338
R524 VSS.n67 VSS.n4 54.8338
R525 VSS.n7 VSS.n4 54.8338
R526 VSS.n7 VSS.n3 54.8338
R527 VSS.n67 VSS.n3 54.8338
R528 VSS.t8 VSS.t12 25.6922
R529 VSS.n71 VSS.n0 18.0724
R530 VSS.n18 VSS.n16 18.0663
R531 VSS.n73 VSS.n71 18.0585
R532 VSS.n16 VSS.n15 18.0572
R533 VSS.n70 VSS.n69 18.0032
R534 VSS.n33 VSS.n32 18.0032
R535 VSS.t6 VSS.t34 17.1283
R536 VSS.n39 VSS.t11 11.3415
R537 VSS.n35 VSS.t5 11.3405
R538 VSS.n55 VSS.t19 10.7115
R539 VSS.n45 VSS.t29 10.7105
R540 VSS.n38 VSS.n35 9.7365
R541 VSS.n59 VSS.n58 9.66255
R542 VSS.n41 VSS.n34 9.09883
R543 VSS.n38 VSS.n37 9.0015
R544 VSS.n46 VSS.n45 9.0015
R545 VSS.n54 VSS.n53 9.0015
R546 VSS.n57 VSS.n12 9.00095
R547 VSS.n40 VSS.n39 9.0005
R548 VSS.n49 VSS.n48 9.0005
R549 VSS.n51 VSS 9.0005
R550 VSS.n56 VSS.n55 9.0005
R551 VSS.n58 VSS.n57 9.0005
R552 VSS.n60 VSS.n59 9.0005
R553 VSS.n42 VSS.n41 9.0005
R554 VSS.n48 VSS.n47 6.3015
R555 VSS VSS.n50 6.3015
R556 VSS.n37 VSS.n36 6.3005
R557 VSS.n53 VSS.n52 6.3005
R558 VSS.n15 VSS.n14 6.3005
R559 VSS.n73 VSS.n72 6.3005
R560 VSS.n36 VSS.t9 5.0405
R561 VSS.n36 VSS.t7 5.0405
R562 VSS.n72 VSS.t1 5.0405
R563 VSS.n72 VSS.t25 5.0405
R564 VSS.n47 VSS.t33 4.4105
R565 VSS.n47 VSS.t31 4.4105
R566 VSS.n50 VSS.t13 4.4105
R567 VSS.n50 VSS.t35 4.4105
R568 VSS.n52 VSS.t17 4.4105
R569 VSS.n52 VSS.t15 4.4105
R570 VSS.n14 VSS.t21 3.2765
R571 VSS.n14 VSS.t23 3.2765
R572 VSS.n44 VSS.n43 2.1555
R573 VSS.n43 VSS.n42 1.94362
R574 VSS.n61 VSS.n12 1.9045
R575 VSS.n61 VSS.n60 1.90352
R576 VSS.n41 VSS.n40 1.6205
R577 VSS.n54 VSS.n51 1.3985
R578 VSS.n51 VSS.n49 1.3925
R579 VSS.n19 VSS.n17 1.0405
R580 VSS.n24 VSS.n19 1.0405
R581 VSS.n26 VSS.n20 1.0405
R582 VSS.n25 VSS.n20 1.0405
R583 VSS.n3 VSS.n2 1.0405
R584 VSS.n21 VSS.n3 1.0405
R585 VSS.n5 VSS.n4 1.0405
R586 VSS.n65 VSS.n4 1.0405
R587 VSS.n40 VSS.n38 0.7385
R588 VSS.n27 VSS.n26 0.7055
R589 VSS.n27 VSS.n17 0.7055
R590 VSS.n6 VSS.n2 0.7055
R591 VSS.n6 VSS.n5 0.7055
R592 VSS.n49 VSS.n46 0.6755
R593 VSS.n56 VSS.n54 0.6725
R594 VSS.n28 VSS.n27 0.5205
R595 VSS.n29 VSS.n28 0.5205
R596 VSS.n31 VSS.n30 0.5205
R597 VSS.n30 VSS.n29 0.5205
R598 VSS.n44 VSS.n11 0.5205
R599 VSS.n11 VSS.n8 0.5205
R600 VSS.n13 VSS.n10 0.5205
R601 VSS.n23 VSS.n10 0.5205
R602 VSS.n68 VSS.n67 0.5205
R603 VSS.n67 VSS.n66 0.5205
R604 VSS.n7 VSS.n6 0.5205
R605 VSS.n66 VSS.n7 0.5205
R606 VSS.n34 VSS.n33 0.458244
R607 VSS.n69 VSS.n68 0.4455
R608 VSS.n68 VSS.n0 0.4455
R609 VSS.n70 VSS.n1 0.441395
R610 VSS.n32 VSS.n31 0.4068
R611 VSS.n31 VSS.n18 0.401147
R612 VSS.n26 VSS.n18 0.286618
R613 VSS.n32 VSS.n17 0.2835
R614 VSS.n13 VSS.n12 0.2515
R615 VSS.n60 VSS.n44 0.250522
R616 VSS.n5 VSS.n0 0.247
R617 VSS.n69 VSS.n2 0.245
R618 VSS.n59 VSS.n46 0.21005
R619 VSS.n42 VSS.n13 0.200618
R620 VSS.n57 VSS.n56 0.1805
R621 VSS.n62 VSS.n61 0.149071
R622 VSS.n63 VSS.n62 0.149071
R623 VSS.n43 VSS.n9 0.149071
R624 VSS.n63 VSS.n9 0.149071
R625 VSS.n58 VSS.n1 0.1013
R626 VSS.n33 VSS.n16 0.0770657
R627 VSS.n71 VSS.n70 0.0666386
R628 VSS.n37 VSS 0.0185
R629 VSS.n34 VSS.n1 0.0184727
R630 VSS.n35 VSS 0.0065
R631 VSS.n39 VSS 0.0055
R632 VSS VSS.n73 0.0045
R633 VSS.n45 VSS 0.0025
R634 VSS.n53 VSS 0.0025
R635 VSS.n15 VSS 0.0025
R636 VSS.n48 VSS 0.0015
R637 VSS.n55 VSS 0.0015
C0 CLKK VIP 0.16096f
C1 AN AP 0.14435f
C2 VIN NT 0.48927f
C3 CLKK VIN 0.05161f
C4 AN ONN 0.22787f
C5 AN CLKN 0
C6 VIP CP 0
C7 CLKN CLK 0.63149f
C8 ON VDD 0.24023f
C9 OPP m3_10090_n11336# 0.01838f
C10 OPP NT 0.0013f
C11 VDD m3_8756_n16674# 0.14041f
C12 OPP CLKK 0.01552f
C13 OPP OP 0.32751f
C14 OPP CP 0.22285f
C15 CN AP 0.00221f
C16 VDD AP 1.87207f
C17 ONN CN 0.34812f
C18 VIN m3_8756_n16674# 0
C19 CLKK NT 0.21382f
C20 VDD ONN 1.75504f
C21 AN CN 1.00428f
C22 CLKN VDD 0.66122f
C23 AN VDD 1.89985f
C24 m3_10090_n11336# CP 0
C25 VIP AP 0.12642f
C26 VIN AP 0.0011f
C27 VDD CLK 0.29443f
C28 ONN VIP 0.00249f
C29 CLKK CP 0
C30 CLKN VIP 0
C31 AN VIP 0.0011f
C32 CLKN VIN 0
C33 AN VIN 0.12813f
C34 ON OPP 0.03646f
C35 VIN CLK 0
C36 ON m3_10090_n11336# 0.04453f
C37 OPP AP 0.30419f
C38 ON OP 0.00583f
C39 NT m3_8756_n16674# 0
C40 OPP ONN 2.68008f
C41 CLKK m3_8756_n16674# 0.02692f
C42 VDD CN 0.36405f
C43 AN OPP 0.33134f
C44 ON CP 0
C45 AP m3_10090_n11336# 0.00251f
C46 ONN m3_10090_n11336# 0.0295f
C47 NT AP 0.18298f
C48 CLKK AP 0.26844f
C49 VDD VIP 1.2258f
C50 ONN NT 0.00117f
C51 VIN CN 0
C52 CLKN NT 0.01337f
C53 VDD VIN 1.29419f
C54 CLKK ONN 0.01487f
C55 AN NT 0.1816f
C56 CLKN CLKK 0.35474f
C57 AN CLKK 0.12282f
C58 ONN OP 0.03638f
C59 AP CP 1.00365f
C60 AN OP 0
C61 NT CLK 0
C62 ONN CP 0.43574f
C63 VIN VIP 0.05926f
C64 CLKK CLK 0.02972f
C65 AN CP 0.00222f
C66 OPP CN 0.31282f
C67 OPP VDD 2.18318f
C68 ON AP 0
C69 ON ONN 0.28264f
C70 VDD m3_10090_n11336# 0.27263f
C71 OPP VIN 0.00238f
C72 CLKN m3_8756_n16674# 0.09452f
C73 CLKK CN 0
C74 VDD NT 2.55227f
C75 CLKK VDD 3.47854f
C76 CN OP 0
C77 VDD OP 0.24069f
C78 CN CP 0.0588f
C79 m3_8756_n16674# CLK 0.0232f
C80 NT VIP 0.48793f
C81 ONN AP 0.25334f
C82 VDD CP 0.32606f
C83 CLKN VSS 0.89432f
C84 CLK VSS 0.39243f
C85 NT VSS 0.70178f
C86 VIP VSS 1.27071f
C87 VIN VSS 0.77907f
C88 CLKK VSS 3.60777f
C89 CP VSS 1.11553f
C90 CN VSS 1.07405f
C91 AP VSS 3.34964f
C92 AN VSS 3.23377f
C93 ON VSS 0.35834f
C94 OP VSS 0.59967f
C95 ONN VSS 2.86292f
C96 OPP VSS 3.62296f
C97 VDD VSS 40.90129f
C98 m3_8756_n16674# VSS 0.28774f $ **FLOATING
C99 m3_10090_n11336# VSS 0.51683f $ **FLOATING
C100 VDD.n0 VSS 0.08416f
C101 VDD.n1 VSS 1.21544f
C102 VDD.n2 VSS 0.03185f
C103 VDD.n3 VSS 0.7128f
C104 VDD.n4 VSS 0.7069f
C105 VDD.t35 VSS 0.49374f
C106 VDD.t34 VSS 0.17894f
C107 VDD.t16 VSS 0.17316f
C108 VDD.t33 VSS 0.17316f
C109 VDD.t14 VSS 0.17316f
C110 VDD.t32 VSS 0.17316f
C111 VDD.t12 VSS 0.03896f
C112 VDD.t30 VSS 0.06061f
C113 VDD.n5 VSS 0.13076f
C114 VDD.t18 VSS 0.44769f
C115 VDD.t6 VSS 0.17316f
C116 VDD.t19 VSS 0.17316f
C117 VDD.t8 VSS 0.17316f
C118 VDD.t20 VSS 0.17316f
C119 VDD.t10 VSS 0.17316f
C120 VDD.t21 VSS 0.02453f
C121 VDD.t36 VSS 0.10678f
C122 VDD.n6 VSS 0.06456f
C123 VDD.n7 VSS 0.08556f
C124 VDD.n8 VSS 0.0064f
C125 VDD.n9 VSS 0.02775f
C126 VDD.n10 VSS 0.08151f
C127 VDD.n11 VSS 0.09174f
C128 VDD.n12 VSS 0.49832f
C129 VDD.n13 VSS 0.08912f
C130 VDD.n14 VSS 0.35288f
C131 VDD.n15 VSS 0.38144f
C132 VDD.t45 VSS 0.00605f
C133 VDD.n16 VSS 0.02005f
C134 VDD.n17 VSS 0.09019f
C135 VDD.n18 VSS 0.14229f
C136 VDD.n19 VSS 0.14229f
C137 VDD.n20 VSS 0.10607f
C138 VDD.t3 VSS 0.00291f
C139 VDD.t41 VSS 0.00291f
C140 VDD.n21 VSS 0.00581f
C141 VDD.n22 VSS 0.01779f
C142 VDD.n23 VSS 0.05902f
C143 VDD.n24 VSS 0.41851f
C144 VDD.n25 VSS 0.09318f
C145 VDD.n26 VSS 0.12209f
C146 VDD.t49 VSS 0.00254f
C147 VDD.t47 VSS 0.00254f
C148 VDD.n27 VSS 0.00509f
C149 VDD.n28 VSS 0.02614f
C150 VDD.t39 VSS 0.00254f
C151 VDD.t51 VSS 0.00254f
C152 VDD.n29 VSS 0.00509f
C153 VDD.n30 VSS 0.02583f
C154 VDD.t1 VSS 0.00254f
C155 VDD.t43 VSS 0.00254f
C156 VDD.n31 VSS 0.00509f
C157 VDD.n32 VSS 0.02579f
C158 VDD.t27 VSS 0.00254f
C159 VDD.t5 VSS 0.00254f
C160 VDD.n33 VSS 0.00509f
C161 VDD.n34 VSS 0.00615f
C162 VDD.n35 VSS 0.02583f
C163 VDD.t23 VSS 0.00254f
C164 VDD.t29 VSS 0.00254f
C165 VDD.n36 VSS 0.00509f
C166 VDD.n37 VSS 0.02618f
C167 VDD.t25 VSS 0.00605f
C168 VDD.n38 VSS 0.02005f
C169 VDD.n39 VSS 0.03196f
C170 VDD.n40 VSS 0.07704f
C171 VDD.n41 VSS 0.01767f
C172 VDD.n42 VSS 0.38221f
C173 VDD.t24 VSS 0.27298f
C174 VDD.t22 VSS 0.2274f
C175 VDD.t28 VSS 0.2274f
C176 VDD.t26 VSS 0.2274f
C177 VDD.t4 VSS 0.2274f
C178 VDD.t0 VSS 0.12033f
C179 VDD.t2 VSS 0.05685f
C180 VDD.n43 VSS 0.10233f
C181 VDD.t40 VSS 0.05685f
C182 VDD.t42 VSS 0.11844f
C183 VDD.t38 VSS 0.2274f
C184 VDD.t50 VSS 0.2274f
C185 VDD.t48 VSS 0.2274f
C186 VDD.t46 VSS 0.2274f
C187 VDD.t44 VSS 0.2731f
C188 VDD.n44 VSS 0.42947f
C189 VDD.n45 VSS 0.01896f
C190 VDD.n46 VSS 0.02192f
C191 VDD.n47 VSS 0.02777f
C192 VDD.n48 VSS 0.15943f
C193 VDD.n49 VSS 0.97978f
C194 VDD.n50 VSS 0.90642f
C195 VDD.n51 VSS 0.88353f
C196 VDD.n52 VSS 0.40241f
C197 VDD.n53 VSS 0.25819f
C198 VDD.n54 VSS 0.20973f
C199 VDD.n55 VSS 0.03547f
C200 VDD.n56 VSS 0.00883f
C201 VDD.n57 VSS 0.00646f
C202 VDD.n58 VSS 0.0306f
C203 VDD.n59 VSS 0.02506f
C204 VDD.t9 VSS 0.00254f
C205 VDD.t7 VSS 0.00254f
C206 VDD.n60 VSS 0.00509f
C207 VDD.n61 VSS 0.03151f
C208 VDD.t13 VSS 0.00254f
C209 VDD.t11 VSS 0.00254f
C210 VDD.n62 VSS 0.00509f
C211 VDD.n63 VSS 0.02583f
C212 VDD.t17 VSS 0.00254f
C213 VDD.t15 VSS 0.00254f
C214 VDD.n64 VSS 0.00509f
C215 VDD.n65 VSS 0.03291f
C216 VDD.n66 VSS 0.02645f
C217 VDD.n67 VSS 0.0282f
C218 VDD.n68 VSS 0.20334f
C219 VDD.n69 VSS 0.25155f
C220 VDD.n70 VSS 0.01104f
C221 VDD.n71 VSS 0.03502f
C222 VDD.n72 VSS 0.00883f
C223 VDD.n73 VSS 0.06468f
C224 VDD.n74 VSS 0.07887f
C225 VDD.n75 VSS 0.08207f
C226 VDD.n76 VSS 0.11544f
C227 VDD.n77 VSS 0.13654f
C228 VDD.n78 VSS 0.08025f
C229 VDD.n79 VSS 0.08205f
C230 VDD.n80 VSS 0.31663f
C231 VDD.n81 VSS 0.39469f
C232 VDD.t31 VSS 0.00189f
C233 VDD.t37 VSS 0.00189f
C234 VDD.n82 VSS 0.00378f
C235 OPP.t4 VSS 0.05265f
C236 OPP.t5 VSS 0.05265f
C237 OPP.n0 VSS 0.10531f
C238 OPP.t7 VSS 0.05677f
C239 OPP.t6 VSS 0.05677f
C240 OPP.n1 VSS 0.98291f
C241 OPP.t11 VSS 0.08542f
C242 OPP.n2 VSS -0.06139f
C243 OPP.t10 VSS 0.08848f
C244 OPP.n3 VSS 0.14644f
C245 OPP.n4 VSS -0.64142f
C246 OPP.t8 VSS 0.16796f
C247 OPP.t9 VSS 0.16796f
C248 OPP.n5 VSS 0.7339f
C249 OPP.n6 VSS 0.26716f
C250 OPP.t0 VSS 0.05265f
C251 OPP.t1 VSS 0.05265f
C252 OPP.n7 VSS 0.10531f
C253 OPP.n8 VSS 0.48187f
C254 OPP.t3 VSS 0.05265f
C255 OPP.t2 VSS 0.05265f
C256 OPP.n9 VSS 0.10531f
C257 OPP.n10 VSS 0.47371f
C258 OPP.n11 VSS 0.99997f
C259 ONN.t5 VSS 0.03875f
C260 ONN.t4 VSS 0.03875f
C261 ONN.n0 VSS 0.07751f
C262 ONN.t0 VSS 0.03875f
C263 ONN.t3 VSS 0.03875f
C264 ONN.n1 VSS 0.07751f
C265 ONN.n2 VSS 0.33373f
C266 ONN.n3 VSS 0.77089f
C267 ONN.t1 VSS 0.03875f
C268 ONN.t2 VSS 0.03875f
C269 ONN.n4 VSS 0.07751f
C270 ONN.n5 VSS 0.40398f
C271 ONN.t11 VSS 0.06288f
C272 ONN.n6 VSS 0.12374f
C273 ONN.t10 VSS 0.06512f
C274 ONN.n7 VSS 0.56748f
C275 ONN.t8 VSS 0.12363f
C276 ONN.t9 VSS 0.12363f
C277 ONN.n8 VSS 0.6244f
C278 ONN.n9 VSS 0.14322f
C279 ONN.t7 VSS 0.04178f
C280 ONN.n10 VSS 0.10985f
C281 ONN.n11 VSS 0.64776f
C282 ONN.t6 VSS 0.03957f
C283 OP.t1 VSS 0.05196f
C284 OP.t0 VSS 0.05073f
C285 OP.n0 VSS 0.22412f
C286 ON.t0 VSS 0.05178f
C287 ON.t1 VSS 0.05042f
C288 ON.n0 VSS 0.25055f
C289 ON.n1 VSS 0.22358f
C290 AN.t13 VSS 0.07237f
C291 AN.t12 VSS 0.07237f
C292 AN.t6 VSS 0.02446f
C293 AN.t0 VSS 0.02593f
C294 AN.t1 VSS 0.02593f
C295 AN.n0 VSS 0.05185f
C296 AN.n1 VSS 0.10941f
C297 AN.n2 VSS 0.19196f
C298 AN.t3 VSS 0.02269f
C299 AN.t2 VSS 0.02269f
C300 AN.n3 VSS 0.04537f
C301 AN.n4 VSS 0.03535f
C302 AN.t5 VSS 0.02269f
C303 AN.t4 VSS 0.02269f
C304 AN.n5 VSS 0.04537f
C305 AN.n6 VSS 0.24828f
C306 AN.n7 VSS 0.70398f
C307 AN.n8 VSS 0.14228f
C308 AN.t7 VSS 0.19465f
C309 AN.n9 VSS 0.06835f
C310 AN.t8 VSS 0.02446f
C311 AN.t9 VSS 0.02446f
C312 AN.n10 VSS 0.41836f
C313 AN.n11 VSS 0.19725f
C314 AN.t11 VSS 0.07237f
C315 AN.n12 VSS 0.21805f
C316 AN.t10 VSS 0.07237f
C317 AP.t6 VSS 0.02633f
C318 AP.t7 VSS 0.02633f
C319 AP.t9 VSS 0.02633f
C320 AP.t1 VSS 0.02791f
C321 AP.t0 VSS 0.02791f
C322 AP.n0 VSS 0.05583f
C323 AP.n1 VSS 0.11947f
C324 AP.n2 VSS 0.20669f
C325 AP.t5 VSS 0.02443f
C326 AP.t4 VSS 0.02443f
C327 AP.n3 VSS 0.04885f
C328 AP.n4 VSS 0.037f
C329 AP.t3 VSS 0.02443f
C330 AP.t2 VSS 0.02443f
C331 AP.n5 VSS 0.04885f
C332 AP.n6 VSS 0.26413f
C333 AP.n7 VSS 0.75795f
C334 AP.n8 VSS 0.15255f
C335 AP.t8 VSS 0.02633f
C336 AP.t10 VSS 0.07792f
C337 AP.t13 VSS 0.07792f
C338 AP.t12 VSS 0.07792f
C339 AP.n9 VSS 0.23515f
C340 AP.n10 VSS 0.21196f
C341 AP.t11 VSS 0.07792f
C342 AP.n11 VSS 0.43767f
C343 CN.t7 VSS 0.02497f
C344 CN.t0 VSS 0.02497f
C345 CN.n0 VSS 0.04993f
C346 CN.t3 VSS 0.02497f
C347 CN.t2 VSS 0.02497f
C348 CN.n1 VSS 0.04993f
C349 CN.t6 VSS 0.02497f
C350 CN.t4 VSS 0.02497f
C351 CN.n2 VSS 0.04993f
C352 CN.n3 VSS 0.51326f
C353 CN.t1 VSS 0.02497f
C354 CN.t5 VSS 0.02497f
C355 CN.n4 VSS 0.04993f
C356 CN.n5 VSS 0.14427f
C357 CN.n6 VSS 0.6927f
C358 CN.n7 VSS 0.16333f
C359 CP.t2 VSS 0.02442f
C360 CP.t3 VSS 0.02442f
C361 CP.n0 VSS 0.04884f
C362 CP.t0 VSS 0.02442f
C363 CP.t5 VSS 0.02442f
C364 CP.n1 VSS 0.04884f
C365 CP.n2 VSS 0.15734f
C366 CP.t4 VSS 0.02442f
C367 CP.t1 VSS 0.02442f
C368 CP.n3 VSS 0.04884f
C369 CP.n4 VSS 0.14124f
C370 CP.n5 VSS 0.68125f
C371 CP.n6 VSS 0.50252f
C372 CP.t6 VSS 0.02442f
C373 CP.t7 VSS 0.02442f
C374 CP.n7 VSS 0.04884f
C375 CLKK.t11 VSS 0.06625f
C376 CLKK.n0 VSS 0.08454f
C377 CLKK.t10 VSS 0.06625f
C378 CLKK.n1 VSS 0.08154f
C379 CLKK.n2 VSS 0.21023f
C380 CLKK.t9 VSS 0.06625f
C381 CLKK.n3 VSS 0.07671f
C382 CLKK.n4 VSS 0.12316f
C383 CLKK.t8 VSS 0.06625f
C384 CLKK.n5 VSS 0.08106f
C385 CLKK.n6 VSS 0.73315f
C386 CLKK.t2 VSS 0.06741f
C387 CLKK.n7 VSS 0.68382f
C388 CLKK.t3 VSS 0.06741f
C389 CLKK.n8 VSS 0.11886f
C390 CLKK.t0 VSS 0.05165f
C391 CLKK.n9 VSS 0.085f
C392 CLKK.t1 VSS 0.05335f
C393 CLKK.n10 VSS 0.36415f
C394 CLKK.t4 VSS 0.06741f
C395 CLKK.n11 VSS 0.10792f
C396 CLKK.n12 VSS 0.14137f
C397 CLKK.n13 VSS 0.10638f
C398 CLKK.t5 VSS 0.06741f
C399 CLKK.n14 VSS 0.07821f
C400 CLKK.n15 VSS 0.11592f
C401 CLKK.t6 VSS 0.06741f
C402 CLKK.n16 VSS 0.19979f
C403 CLKK.t7 VSS 0.06741f
C404 CLKK.n17 VSS 0.08128f
C405 VIN.t0 VSS 0.22471f
C406 VIN.t3 VSS 0.2246f
C407 VIN.n0 VSS 0.2299f
C408 VIN.t2 VSS 0.22471f
C409 VIN.n1 VSS 0.26679f
C410 VIN.n2 VSS -0.74982f
C411 VIN.t1 VSS 0.2246f
C412 VIN.n3 VSS 0.65508f
C413 VIN.n4 VSS 0.27092f
C414 VIP.t3 VSS 0.23246f
C415 VIP.t2 VSS 0.23249f
C416 VIP.n0 VSS 0.25937f
C417 VIP.n1 VSS 0.67761f
C418 VIP.t1 VSS 0.23242f
C419 VIP.n2 VSS -0.79659f
C420 VIP.t0 VSS 0.23238f
C421 NT.t11 VSS 0.0609f
C422 NT.t4 VSS 0.0609f
C423 NT.n0 VSS 0.18069f
C424 NT.t8 VSS 0.0609f
C425 NT.n1 VSS 0.14533f
C426 NT.n2 VSS 0.39326f
C427 NT.t1 VSS 0.02559f
C428 NT.t10 VSS 0.02559f
C429 NT.n3 VSS 0.05118f
C430 NT.n4 VSS 0.13687f
C431 NT.n5 VSS 0.23236f
C432 NT.t6 VSS 0.02559f
C433 NT.t7 VSS 0.02559f
C434 NT.n6 VSS 0.05119f
C435 NT.n7 VSS 0.20349f
C436 NT.t12 VSS 0.02559f
C437 NT.t0 VSS 0.02559f
C438 NT.n8 VSS 0.05118f
C439 NT.n9 VSS 0.13687f
C440 NT.n10 VSS 0.22929f
C441 NT.t9 VSS 0.02559f
C442 NT.t5 VSS 0.02559f
C443 NT.n11 VSS 0.05119f
C444 NT.n12 VSS 0.20349f
C445 NT.t13 VSS 0.02559f
C446 NT.t3 VSS 0.02559f
C447 NT.n13 VSS 0.05118f
C448 NT.n14 VSS 0.13863f
C449 NT.n15 VSS 0.23236f
C450 NT.t2 VSS 0.06091f
C451 NT.n16 VSS 0.39578f
C452 NT.n17 VSS 0.17746f
C453 CLK.t0 VSS 0.07166f
C454 CLK.n0 VSS 0.3744f
C455 CLK.t1 VSS 0.07422f
C456 CLK.n1 VSS 0.37975f
C457 CLKN.t2 VSS 0.04716f
C458 CLKN.t1 VSS 0.06849f
C459 CLKN.n0 VSS 0.08117f
C460 CLKN.t0 VSS 0.07105f
C461 CLKN.n1 VSS 0.0766f
C462 CLKN.n2 VSS 0.63821f
C463 CLKN.n3 VSS 0.36472f
C464 CLKN.n4 VSS 0.01927f
C465 CLKN.t3 VSS 0.04884f
C466 CLKN.n5 VSS 0.07951f
C467 CLKN.n6 VSS 0.07923f
.ends
