* NGSPICE file created from strongARM.ext - technology: gf180mcuD

.subckt pfet a_460_160# a_742_0# a_28_160# w_n180_n88# a_526_0# a_244_160# a_n92_0#
+ a_676_160# a_310_0# a_94_0# VSUBS
X0 a_526_0# a_460_160# a_310_0# w_n180_n88# pfet_03v3 ad=0.2p pd=1.3u as=0.2p ps=1.3u w=0.5u l=0.28u
X1 a_94_0# a_28_160# a_n92_0# w_n180_n88# pfet_03v3 ad=0.2p pd=1.3u as=0.325p ps=2.3u w=0.5u l=0.28u
X2 a_310_0# a_244_160# a_94_0# w_n180_n88# pfet_03v3 ad=0.2p pd=1.3u as=0.2p ps=1.3u w=0.5u l=0.28u
X3 a_742_0# a_676_160# a_526_0# w_n180_n88# pfet_03v3 ad=0.325p pd=2.3u as=0.2p ps=1.3u w=0.5u l=0.28u
C0 w_n180_n88# a_742_0# 0.00716f
C1 a_310_0# a_94_0# 0.02606f
C2 a_n92_0# a_28_160# 0.00321f
C3 a_94_0# a_28_160# 0.00325f
C4 w_n180_n88# a_460_160# 0.08515f
C5 w_n180_n88# a_n92_0# 0.00716f
C6 a_310_0# a_244_160# 0.00325f
C7 w_n180_n88# a_676_160# 0.08879f
C8 w_n180_n88# a_94_0# 0.00477f
C9 a_676_160# a_742_0# 0.00321f
C10 a_28_160# a_244_160# 0.03905f
C11 a_676_160# a_460_160# 0.03905f
C12 a_310_0# a_526_0# 0.02606f
C13 w_n180_n88# a_244_160# 0.08515f
C14 a_n92_0# a_94_0# 0.02545f
C15 a_244_160# a_460_160# 0.03905f
C16 w_n180_n88# a_526_0# 0.00477f
C17 a_526_0# a_742_0# 0.02545f
C18 a_94_0# a_244_160# 0.00325f
C19 a_526_0# a_460_160# 0.00325f
C20 a_310_0# w_n180_n88# 0.00477f
C21 w_n180_n88# a_28_160# 0.08879f
C22 a_676_160# a_526_0# 0.00325f
C23 a_310_0# a_460_160# 0.00325f
C24 a_742_0# VSUBS 0.0369f
C25 a_526_0# VSUBS 0.02453f
C26 a_310_0# VSUBS 0.02453f
C27 a_94_0# VSUBS 0.02453f
C28 a_n92_0# VSUBS 0.0369f
C29 a_676_160# VSUBS 0.11073f
C30 a_460_160# VSUBS 0.08611f
C31 a_244_160# VSUBS 0.08611f
C32 a_28_160# VSUBS 0.11073f
C33 w_n180_n88# VSUBS 0.94392f
.ends

.subckt strongARM VDD CLK ON OP VIN VIP VSS
Xpfet_0 OPP VDD ONN VDD OP ONN VDD OPP VDD ON VSS pfet
X0 AN VIN NT VDD pfet_03v3 ad=0.175p pd=1.2u as=0.175p ps=1.2u w=0.5u l=0.5u
X1 VDD AN CN VDD pfet_03v3 ad=0.175p pd=1.2u as=0.175p ps=1.2u w=0.5u l=0.5u
X2 VSS AN CN VSS nfet_03v3 ad=0.175p pd=1.2u as=0.175p ps=1.2u w=0.5u l=0.5u
X3 AP VIP NT VDD pfet_03v3 ad=0.175p pd=1.2u as=0.175p ps=1.2u w=0.5u l=0.5u
X4 NT VIP AP VDD pfet_03v3 ad=0.175p pd=1.2u as=0.175p ps=1.2u w=0.5u l=0.5u
X5 NT VIN AN VDD pfet_03v3 ad=0.175p pd=1.2u as=0.175p ps=1.2u w=0.5u l=0.5u
X6 VDD CLKK NT VDD pfet_03v3 ad=0.175p pd=1.2u as=0.325p ps=2.3u w=0.5u l=0.5u
X7 OPP ONN VDD VDD pfet_03v3 ad=0.175p pd=1.2u as=0.175p ps=1.2u w=0.5u l=0.5u
X8 VDD AN ONN VDD pfet_03v3 ad=0.175p pd=1.2u as=0.175p ps=1.2u w=0.5u l=0.5u
X9 AP CLKK VSS VSS nfet_03v3 ad=0.175p pd=1.2u as=0.305p ps=2.22u w=0.5u l=0.5u
X10 ONN OPP CN VSS nfet_03v3 ad=0.175p pd=1.2u as=0.175p ps=1.2u w=0.5u l=0.5u
X11 CP AP VSS VSS nfet_03v3 ad=0.175p pd=1.2u as=0.175p ps=1.2u w=0.5u l=0.5u
X12 VDD CLKK NT VDD pfet_03v3 ad=0.175p pd=1.2u as=0.175p ps=1.2u w=0.5u l=0.5u
X13 NT CLKK VDD VDD pfet_03v3 ad=0.175p pd=1.2u as=0.175p ps=1.2u w=0.5u l=0.5u
X14 CN AN VDD VDD pfet_03v3 ad=0.175p pd=1.2u as=0.325p ps=2.3u w=0.5u l=0.5u
X15 VDD AP OPP VDD pfet_03v3 ad=0.175p pd=1.2u as=0.175p ps=1.2u w=0.5u l=0.5u
X16 CN AN VSS VSS nfet_03v3 ad=0.175p pd=1.2u as=0.175p ps=1.2u w=0.5u l=0.5u
X17 VSS AP CP VSS nfet_03v3 ad=0.175p pd=1.2u as=0.175p ps=1.2u w=0.5u l=0.5u
X18 VSS CLKN CLKK VSS nfet_03v3 ad=0.13p pd=1.02u as=0.305p ps=2.22u w=0.5u l=0.28u
X19 NT CLKK VDD VDD pfet_03v3 ad=0.325p pd=2.3u as=0.175p ps=1.2u w=0.5u l=0.5u
X20 VDD AP CP VDD pfet_03v3 ad=0.325p pd=2.3u as=0.175p ps=1.2u w=0.5u l=0.5u
X21 VDD CLK CLKN VDD pfet_03v3 ad=0.325p pd=2.3u as=0.13p ps=1.02u w=0.5u l=0.28u
X22 OPP AP VDD VDD pfet_03v3 ad=0.175p pd=1.2u as=0.175p ps=1.2u w=0.5u l=0.5u
X23 CP ONN OPP VSS nfet_03v3 ad=0.175p pd=1.2u as=0.175p ps=1.2u w=0.5u l=0.5u
X24 VSS AP CP VSS nfet_03v3 ad=0.175p pd=1.2u as=0.175p ps=1.2u w=0.5u l=0.5u
X25 NT VIP AP VDD pfet_03v3 ad=0.175p pd=1.2u as=0.325p ps=2.3u w=0.5u l=0.5u
X26 CLKK CLKN VDD VDD pfet_03v3 ad=0.13p pd=1.02u as=0.325p ps=2.3u w=0.5u l=0.28u
X27 CLKN CLK VSS VSS nfet_03v3 ad=0.305p pd=2.22u as=0.13p ps=1.02u w=0.5u l=0.28u
X28 NT VIN AN VDD pfet_03v3 ad=0.175p pd=1.2u as=0.175p ps=1.2u w=0.5u l=0.5u
X29 AN VIN NT VDD pfet_03v3 ad=0.175p pd=1.2u as=0.175p ps=1.2u w=0.5u l=0.5u
X30 ONN AN VDD VDD pfet_03v3 ad=0.175p pd=1.2u as=0.175p ps=1.2u w=0.5u l=0.5u
X31 CN AN VSS VSS nfet_03v3 ad=0.175p pd=1.2u as=0.175p ps=1.2u w=0.5u l=0.5u
X32 AP VIP NT VDD pfet_03v3 ad=0.325p pd=2.3u as=0.175p ps=1.2u w=0.5u l=0.5u
X33 ONN OPP VDD VDD pfet_03v3 ad=0.175p pd=1.2u as=0.175p ps=1.2u w=0.5u l=0.5u
X34 VSS CLKK AP VSS nfet_03v3 ad=0.175p pd=1.2u as=0.175p ps=1.2u w=0.5u l=0.5u
X35 VDD OPP ONN VDD pfet_03v3 ad=0.175p pd=1.2u as=0.175p ps=1.2u w=0.5u l=0.5u
X36 CN OPP ONN VSS nfet_03v3 ad=0.175p pd=1.2u as=0.175p ps=1.2u w=0.5u l=0.5u
X37 VSS AN CN VSS nfet_03v3 ad=0.175p pd=1.2u as=0.175p ps=1.2u w=0.5u l=0.5u
X38 NT CLKK VDD VDD pfet_03v3 ad=0.175p pd=1.2u as=0.175p ps=1.2u w=0.5u l=0.5u
X39 VDD CLKK NT VDD pfet_03v3 ad=0.175p pd=1.2u as=0.175p ps=1.2u w=0.5u l=0.5u
X40 VDD ONN OPP VDD pfet_03v3 ad=0.175p pd=1.2u as=0.175p ps=1.2u w=0.5u l=0.5u
X41 VDD CLKN CLKK VDD pfet_03v3 ad=0.13p pd=1.02u as=0.13p ps=1.02u w=0.5u l=0.28u
X42 OPP ONN CP VSS nfet_03v3 ad=0.175p pd=1.2u as=0.175p ps=1.2u w=0.5u l=0.5u
X43 CP AP VDD VDD pfet_03v3 ad=0.175p pd=1.2u as=0.175p ps=1.2u w=0.5u l=0.5u
X44 CP AP VSS VSS nfet_03v3 ad=0.175p pd=1.2u as=0.175p ps=1.2u w=0.5u l=0.5u
X45 VSS OPP OP VSS nfet_03v3 ad=0.2p pd=1.3u as=0.305p ps=2.22u w=0.5u l=0.28u
X46 CLKN CLK VDD VDD pfet_03v3 ad=0.13p pd=1.02u as=0.13p ps=1.02u w=0.5u l=0.28u
X47 AN CLKK VSS VSS nfet_03v3 ad=0.175p pd=1.2u as=0.175p ps=1.2u w=0.5u l=0.5u
X48 VSS CLKK AN VSS nfet_03v3 ad=0.305p pd=2.22u as=0.175p ps=1.2u w=0.5u l=0.5u
X49 ON ONN VSS VSS nfet_03v3 ad=0.305p pd=2.22u as=0.2p ps=1.3u w=0.5u l=0.28u
C0 NT AP 0.17804f
C1 VDD AN 4.42648f
C2 CN OPP 0.53677f
C3 CLKK VDD 6.85874f
C4 AP VDD 2.97366f
C5 ONN ON 0.16933f
C6 CN AN 1.08981f
C7 CN CLKK 0.00566f
C8 AP CN 0.06996f
C9 CLKN CLK 0.95093f
C10 VDD ON 0.38351f
C11 CLKN CLKK 0.45919f
C12 CLKN AP 0.00134f
C13 NT VIP 0.35055f
C14 OPP AN 0.29821f
C15 NT VIN 0.38201f
C16 CLKK OPP 0.14561f
C17 AP OPP 0.84722f
C18 CLK CLKK 0.06987f
C19 VIP VDD 1.71462f
C20 AP CLK 0
C21 VIN VDD 1.8944f
C22 CP OP 0
C23 CLKK AN 0.50985f
C24 AP AN 0.26152f
C25 ONN OP 0.06774f
C26 AP CLKK 0.21244f
C27 VIP CN 0
C28 VIN CN 0.00198f
C29 OPP ON 0.02327f
C30 VDD OP 0.33286f
C31 CLKN VIP 0.00364f
C32 CLKN VIN 0.00112f
C33 ONN CP 0.49768f
C34 ON AN 0
C35 CLKK ON 0
C36 AP ON 0
C37 VIP CLK 0
C38 VIN CLK 0
C39 VDD CP 0.04536f
C40 VIP AN 0.18938f
C41 VIN AN 0.95368f
C42 ONN VDD 1.6235f
C43 VIP CLKK 0.26952f
C44 VIN CLKK 0.0117f
C45 VIP AP 0.12457f
C46 VIN AP 0.72024f
C47 NT VDD 2.71172f
C48 CN CP 0.0249f
C49 OPP OP 0.20411f
C50 ONN CN 0.01009f
C51 NT CN 0
C52 AN OP 0.01241f
C53 CLKK OP 0.08f
C54 AP OP 0
C55 CN VDD 0.05271f
C56 NT CLKN 0.02105f
C57 OPP CP 0.05288f
C58 ONN OPP 2.23809f
C59 CP AN 0.01012f
C60 CLKN VDD 1.04974f
C61 VIP VIN 0.81566f
C62 ONN AN 1.277f
C63 CLKK CP 0.00558f
C64 AP CP 1.14569f
C65 NT CLK 0.01322f
C66 ON OP 0.16443f
C67 ONN CLKK 0.24425f
C68 NT AN 0.29855f
C69 AP ONN 0.65213f
C70 VDD OPP 1.31193f
C71 NT CLKK 0.48468f
C72 CLK VDD 0.57077f
C73 VIN VSS 0.21212f
C74 VIP VSS 0.18362f
C75 CP VSS 1.1113f
C76 CN VSS 1.06351f
C77 NT VSS 0.0461f
C78 AP VSS 3.74932f
C79 AN VSS 2.07027f
C80 CLKK VSS 1.84244f
C81 CLKN VSS 0.6321f
C82 CLK VSS 0.67007f
C83 VDD VSS 40.32648f
C84 OP VSS 0.2045f
C85 ON VSS 0.3806f
C86 OPP VSS 2.39279f
C87 ONN VSS 1.31261f
.ends
