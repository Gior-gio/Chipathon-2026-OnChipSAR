* NGSPICE file created from strongARM.ext - technology: gf180mcuD

.subckt pfet a_28_160# w_n180_n88# a_244_160# a_n92_0# a_310_0# a_94_0# VSUBS
X0 a_94_0# a_28_160# a_n92_0# w_n180_n88# pfet_03v3 ad=0.2p pd=1.3u as=0.325p ps=2.3u w=0.5u l=0.28u
X1 a_310_0# a_244_160# a_94_0# w_n180_n88# pfet_03v3 ad=0.325p pd=2.3u as=0.2p ps=1.3u w=0.5u l=0.28u
C0 a_94_0# w_n180_n88# 0.00477f
C1 a_94_0# a_244_160# 0.00325f
C2 a_28_160# a_n92_0# 0.00321f
C3 a_n92_0# w_n180_n88# 0.00716f
C4 a_28_160# w_n180_n88# 0.08879f
C5 a_28_160# a_244_160# 0.03905f
C6 a_244_160# w_n180_n88# 0.08879f
C7 a_94_0# a_310_0# 0.02545f
C8 a_310_0# w_n180_n88# 0.00716f
C9 a_310_0# a_244_160# 0.00321f
C10 a_94_0# a_n92_0# 0.02545f
C11 a_94_0# a_28_160# 0.00325f
C12 a_310_0# VSUBS 0.0369f
C13 a_94_0# VSUBS 0.02453f
C14 a_n92_0# VSUBS 0.0369f
C15 a_244_160# VSUBS 0.11073f
C16 a_28_160# VSUBS 0.11073f
C17 w_n180_n88# VSUBS 0.58622f
.ends

.subckt nfet a_658_0# a_298_n60# a_398_0# a_38_n60# a_558_n60# a_n84_0# a_918_0# a_138_0#
+ a_818_n60# VSUBS
X0 a_658_0# a_558_n60# a_398_0# VSUBS nfet_03v3 ad=0.2p pd=1.3u as=0.2p ps=1.3u w=0.5u l=0.5u
X1 a_398_0# a_298_n60# a_138_0# VSUBS nfet_03v3 ad=0.2p pd=1.3u as=0.2p ps=1.3u w=0.5u l=0.5u
X2 a_138_0# a_38_n60# a_n84_0# VSUBS nfet_03v3 ad=0.2p pd=1.3u as=0.305p ps=2.22u w=0.5u l=0.5u
X3 a_918_0# a_818_n60# a_658_0# VSUBS nfet_03v3 ad=0.305p pd=2.22u as=0.2p ps=1.3u w=0.5u l=0.5u
C0 a_n84_0# a_38_n60# 0.00472f
C1 a_558_n60# a_658_0# 0.00472f
C2 a_658_0# a_918_0# 0.01985f
C3 a_138_0# a_398_0# 0.01985f
C4 a_298_n60# a_38_n60# 0.03264f
C5 a_558_n60# a_818_n60# 0.03264f
C6 a_298_n60# a_558_n60# 0.03264f
C7 a_818_n60# a_918_0# 0.00472f
C8 a_658_0# a_398_0# 0.01985f
C9 a_n84_0# a_138_0# 0.01985f
C10 a_298_n60# a_398_0# 0.00472f
C11 a_298_n60# a_138_0# 0.00472f
C12 a_138_0# a_38_n60# 0.00472f
C13 a_558_n60# a_398_0# 0.00472f
C14 a_658_0# a_818_n60# 0.00472f
C15 a_918_0# VSUBS 0.04417f
C16 a_658_0# VSUBS 0.0293f
C17 a_398_0# VSUBS 0.0293f
C18 a_138_0# VSUBS 0.0293f
C19 a_n84_0# VSUBS 0.04417f
C20 a_818_n60# VSUBS 0.22873f
C21 a_558_n60# VSUBS 0.20227f
C22 a_298_n60# VSUBS 0.20227f
C23 a_38_n60# VSUBS 0.22873f
.ends

.subckt strongARM AP AN VIP VIN NT ONN ON VDD OPP CP VSS OP CN CLKK CLKN CLK
Xpfet_0 ONN w_8240_n12868# OPP ON OP VDD pfet_0/VSUBS pfet
Xnfet_0 AP CLKK VSS CLKK CLKK VSS VSS AN CLKK pfet_0/VSUBS nfet
X0 OPP.t5 ONN.t8 VDD.t16 w_8240_n12868# pfet_03v3 ad=0.175p pd=1.2u as=0.175p ps=1.2u w=0.5u l=0.5u
X1 VDD.t7 AN.t8 ONN.t1 w_8240_n12868# pfet_03v3 ad=0.175p pd=1.2u as=0.175p ps=1.2u w=0.5u l=0.5u
X2 OPP.t2 AP.t11 VDD.t6 w_8240_n12868# pfet_03v3 ad=0.175p pd=1.2u as=0.175p ps=1.2u w=0.5u l=0.5u
X3 AN.t0 VIN.t3 NT.t0 w_8626_n16372# pfet_03v3 ad=0.175p pd=1.2u as=0.325p ps=2.3u w=0.5u l=0.5u
X4 NT.t1 VIP.t2 AP.t0 w_8626_n16372# pfet_03v3 ad=0.175p pd=1.2u as=0.175p ps=1.2u w=0.5u l=0.5u
X5 a_9960_n15971# CLK.t1 CLKN.t0 w_8626_n16372# pfet_03v3 ad=0.13p pd=1.02u as=0.305p ps=2.22u w=0.5u l=0.28u
X6 VDD.t1 OPP.t8 ONN.t4 w_8240_n12868# pfet_03v3 ad=0.175p pd=1.2u as=0.175p ps=1.2u w=0.5u l=0.5u
X7 AN.t3 VIN.t1 NT.t6 w_8626_n16372# pfet_03v3 ad=0.175p pd=1.2u as=0.175p ps=1.2u w=0.5u l=0.5u
X8 a_11398_n12302# AP.t8 CP.t3 w_8240_n12868# pfet_03v3 ad=0.325p pd=2.3u as=0.175p ps=1.2u w=0.5u l=0.5u
X9 NT.t4 VIP.t0 AP.t1 w_8626_n16372# pfet_03v3 ad=0.325p pd=2.3u as=0.175p ps=1.2u w=0.5u l=0.5u
X10 NT.t10 CLKK.t4 VDD.t12 w_8626_n16372# pfet_03v3 ad=0.175p pd=1.2u as=0.175p ps=1.2u w=0.5u l=0.5u
X11 ON.t0 ONN.t9 VSS.t3 pfet_0/VSUBS nfet_03v3 ad=0.305p pd=2.22u as=0.2p ps=1.3u w=0.5u l=0.28u
X12 CN.t2 AN.t7 VSS.t2 pfet_0/VSUBS nfet_03v3 ad=0.175p pd=1.2u as=0.31p ps=2.24u w=0.5u l=0.5u
X13 VDD.t5 CLKK.t7 NT.t7 w_8626_n16372# pfet_03v3 ad=0.175p pd=1.2u as=0.325p ps=2.3u w=0.5u l=0.5u
X14 NT.t12 CLKK.t2 VDD.t0 w_8626_n16372# pfet_03v3 ad=0.325p pd=2.3u as=0.175p ps=1.2u w=0.5u l=0.5u
X15 CP.t4 AP.t7 VSS.t0 pfet_0/VSUBS nfet_03v3 ad=0.175p pd=1.2u as=0.175p ps=1.2u w=0.5u l=0.5u
X16 CLKK.t0 CLKN.t2 a_9964_n16840# pfet_0/VSUBS nfet_03v3 ad=0.305p pd=2.22u as=0.13p ps=1.02u w=0.5u l=0.28u
X17 VSS.t1 OPP.t10 OP.t0 pfet_0/VSUBS nfet_03v3 ad=0.2p pd=1.3u as=0.305p ps=2.22u w=0.5u l=0.28u
X18 VDD.t13 CLKK.t5 NT.t9 w_8626_n16372# pfet_03v3 ad=0.175p pd=1.2u as=0.175p ps=1.2u w=0.5u l=0.5u
X19 ONN.t5 OPP.t7 CN.t6 pfet_0/VSUBS nfet_03v3 ad=0.175p pd=1.2u as=0.175p ps=1.2u w=0.5u l=0.5u
X20 CP.t6 ONN.t6 OPP.t3 pfet_0/VSUBS nfet_03v3 ad=0.175p pd=1.2u as=0.175p ps=1.2u w=0.5u l=0.5u
X21 ONN.t0 AN.t9 VDD.t8 w_8240_n12868# pfet_03v3 ad=0.175p pd=1.2u as=0.175p ps=1.2u w=0.5u l=0.5u
X22 VDD.t15 ONN.t7 OPP.t4 w_8240_n12868# pfet_03v3 ad=0.175p pd=1.2u as=0.175p ps=1.2u w=0.5u l=0.5u
X23 VSS.t4 AN.t4 CN.t3 pfet_0/VSUBS nfet_03v3 ad=0.175p pd=1.2u as=0.175p ps=1.2u w=0.5u l=0.5u
X24 VSS.t5 AP.t4 CP.t5 pfet_0/VSUBS nfet_03v3 ad=0.32p pd=2.28u as=0.175p ps=1.2u w=0.5u l=0.5u
X25 ONN.t3 OPP.t9 VDD.t2 w_8240_n12868# pfet_03v3 ad=0.175p pd=1.2u as=0.175p ps=1.2u w=0.5u l=0.5u
X26 VDD.t4 AP.t10 OPP.t1 w_8240_n12868# pfet_03v3 ad=0.175p pd=1.2u as=0.175p ps=1.2u w=0.5u l=0.5u
X27 VDD.t9 AN.t10 CN.t1 w_8240_n12868# pfet_03v3 ad=0.175p pd=1.2u as=0.175p ps=1.2u w=0.5u l=0.5u
X28 CP.t0 AP.t9 VDD.t3 w_8240_n12868# pfet_03v3 ad=0.175p pd=1.2u as=0.175p ps=1.2u w=0.5u l=0.5u
X29 AP.t3 VIP.t3 NT.t13 w_8626_n16372# pfet_03v3 ad=0.175p pd=1.2u as=0.175p ps=1.2u w=0.5u l=0.5u
X30 a_9964_n16840# CLK.t0 CLKN.t1 pfet_0/VSUBS nfet_03v3 ad=0.13p pd=1.02u as=0.305p ps=2.22u w=0.5u l=0.28u
X31 NT.t2 VIN.t2 AN.t1 w_8626_n16372# pfet_03v3 ad=0.175p pd=1.2u as=0.175p ps=1.2u w=0.5u l=0.5u
X32 AP.t2 VIP.t1 NT.t5 w_8626_n16372# pfet_03v3 ad=0.175p pd=1.2u as=0.175p ps=1.2u w=0.5u l=0.5u
X33 NT.t3 VIN.t0 AN.t2 w_8626_n16372# pfet_03v3 ad=0.175p pd=1.2u as=0.175p ps=1.2u w=0.5u l=0.5u
X34 VDD.t11 CLKK.t3 NT.t11 w_8626_n16372# pfet_03v3 ad=0.175p pd=1.2u as=0.175p ps=1.2u w=0.5u l=0.5u
X35 NT.t8 CLKK.t6 VDD.t14 w_8626_n16372# pfet_03v3 ad=0.175p pd=1.2u as=0.175p ps=1.2u w=0.5u l=0.5u
X36 CLKK.t1 a_10054_n16107# a_9960_n15971# w_8626_n16372# pfet_03v3 ad=0.33p pd=2.32u as=0.13p ps=1.02u w=0.5u l=0.28u
X37 CN.t5 AN.t5 a_8996_n13492# pfet_0/VSUBS nfet_03v3 ad=0.175p pd=1.2u as=0.175p ps=1.2u w=0.5u l=0.5u
X38 OPP.t0 a_10336_n13624# CP.t7 pfet_0/VSUBS nfet_03v3 ad=0.175p pd=1.2u as=0.175p ps=1.2u w=0.5u l=0.5u
X39 CN.t7 OPP.t6 ONN.t2 pfet_0/VSUBS nfet_03v3 ad=0.175p pd=1.2u as=0.175p ps=1.2u w=0.5u l=0.5u
X40 a_8996_n13492# AN.t6 CN.t4 pfet_0/VSUBS nfet_03v3 ad=0.175p pd=1.2u as=0.175p ps=1.2u w=0.5u l=0.5u
X41 a_10916_n13492# AP.t6 CP.t1 pfet_0/VSUBS nfet_03v3 ad=0.175p pd=1.2u as=0.175p ps=1.2u w=0.5u l=0.5u
X42 CP.t2 AP.t5 a_10916_n13492# pfet_0/VSUBS nfet_03v3 ad=0.175p pd=1.2u as=0.175p ps=1.2u w=0.5u l=0.5u
X43 CN.t0 AN.t11 VDD.t10 w_8240_n12868# pfet_03v3 ad=0.175p pd=1.2u as=0.325p ps=2.3u w=0.5u l=0.5u
R0 VSS.n0 VSS 18.5943
R1 VSS.n14 VSS.n12 18.5664
R2 VSS.n11 VSS.n3 18.4294
R3 VSS.n9 VSS.t5 10.7115
R4 VSS.n4 VSS.t2 10.7105
R5 VSS.n1 VSS 9.7425
R6 VSS.n5 VSS.n4 9.6765
R7 VSS.n12 VSS.n11 9.1013
R8 VSS.n3 VSS.n0 9.09883
R9 VSS.n1 VSS 9.0195
R10 VSS.n2 VSS 9.0055
R11 VSS.n8 VSS 9.0035
R12 VSS.n5 VSS 9.0015
R13 VSS.n7 VSS 9.0005
R14 VSS.n10 VSS.n9 9.0005
R15 VSS VSS.n6 6.3015
R16 VSS.n14 VSS.n13 6.3005
R17 VSS.n13 VSS.t3 5.0405
R18 VSS.n13 VSS.t1 5.0405
R19 VSS.n6 VSS.t0 4.4105
R20 VSS.n6 VSS.t4 4.4105
R21 VSS.n3 VSS.n2 1.6205
R22 VSS.n8 VSS.n7 1.3985
R23 VSS.n7 VSS.n5 1.3925
R24 VSS.n2 VSS.n1 0.7385
R25 VSS.n10 VSS.n8 0.6725
R26 VSS.n11 VSS.n10 0.1805
R27 VSS.n12 VSS.n0 0.0184727
R28 VSS VSS.n14 0.0045
R29 VSS.n4 VSS 0.0025
R30 VSS.n9 VSS 0.0015
R31 VDD.n30 VDD.n29 18.512
R32 VDD.n21 VDD.n20 18.3256
R33 VDD.n31 VDD.n4 18.2525
R34 VDD.n26 VDD.n6 18.097
R35 VDD.n4 VDD 18.0425
R36 VDD.n20 VDD 18.0412
R37 VDD.n24 VDD.n23 18.0014
R38 VDD.n33 VDD.n32 18.0014
R39 VDD.n5 VDD.n1 13.5032
R40 VDD VDD.t10 11.0805
R41 VDD.n8 VDD 9.7005
R42 VDD VDD.n41 9.6765
R43 VDD.n28 VDD.n27 9.30124
R44 VDD.n25 VDD.n19 9.08911
R45 VDD.n18 VDD 9.0015
R46 VDD.n17 VDD 9.0015
R47 VDD.n15 VDD 9.0015
R48 VDD.n13 VDD 9.0015
R49 VDD.n11 VDD.n10 9.0015
R50 VDD.n8 VDD 9.0015
R51 VDD.n39 VDD 9.0015
R52 VDD.n41 VDD 9.0015
R53 VDD.n22 VDD.n19 9.0005
R54 VDD.n37 VDD.n0 9.0005
R55 VDD VDD.n16 5.2005
R56 VDD VDD.n14 5.2005
R57 VDD VDD.n12 5.2005
R58 VDD.n10 VDD.n9 5.2005
R59 VDD VDD.n7 5.2005
R60 VDD VDD.n38 5.2005
R61 VDD VDD.n40 5.2005
R62 VDD VDD.n42 5.2005
R63 VDD.n16 VDD.t8 4.9005
R64 VDD.n16 VDD.t9 4.9005
R65 VDD.n14 VDD.t2 4.9005
R66 VDD.n14 VDD.t7 4.9005
R67 VDD.n12 VDD.t16 4.9005
R68 VDD.n12 VDD.t1 4.9005
R69 VDD.n9 VDD.t6 4.9005
R70 VDD.n9 VDD.t15 4.9005
R71 VDD.n7 VDD.t3 4.9005
R72 VDD.n7 VDD.t4 4.9005
R73 VDD.n38 VDD.t14 4.9005
R74 VDD.n38 VDD.t5 4.9005
R75 VDD.n40 VDD.t12 4.9005
R76 VDD.n40 VDD.t13 4.9005
R77 VDD.n42 VDD.t0 4.9005
R78 VDD.n42 VDD.t11 4.9005
R79 VDD.n37 VDD.n36 4.5014
R80 VDD.n2 VDD.n1 4.5005
R81 VDD.n36 VDD.n35 4.5005
R82 VDD.n21 VDD.n6 4.2498
R83 VDD.n23 VDD.n21 3.24415
R84 VDD.n32 VDD.n31 2.454
R85 VDD.n39 VDD.n37 1.0655
R86 VDD.n31 VDD.n30 0.8342
R87 VDD.n30 VDD.n28 0.747487
R88 VDD.n28 VDD.n5 0.73798
R89 VDD.n18 VDD.n17 0.6935
R90 VDD.n32 VDD.n0 0.6805
R91 VDD.n17 VDD.n15 0.6785
R92 VDD.n11 VDD.n8 0.6755
R93 VDD.n13 VDD.n11 0.6755
R94 VDD.n41 VDD.n39 0.6755
R95 VDD.n15 VDD.n13 0.6725
R96 VDD.n23 VDD.n22 0.565618
R97 VDD.n22 VDD.n6 0.500735
R98 VDD.n24 VDD.n20 0.320361
R99 VDD.n19 VDD.n18 0.2555
R100 VDD.n33 VDD.n4 0.235646
R101 VDD.n34 VDD.n33 0.204627
R102 VDD.n5 VDD.n0 0.1805
R103 VDD.n35 VDD.n34 0.1741
R104 VDD.n29 VDD.n3 0.173815
R105 VDD.n25 VDD.n24 0.107202
R106 VDD.n36 VDD.n1 0.0824
R107 VDD.n27 VDD.n26 0.0758092
R108 VDD.n27 VDD.n3 0.0278774
R109 VDD.n26 VDD.n25 0.0217793
R110 VDD.n35 VDD.n2 0.0169
R111 VDD.n34 VDD.n3 0.0155959
R112 VDD.n29 VDD.n2 0.0145
R113 VDD.n10 VDD 0.0065
R114 OPP.n4 OPP.n3 25.9898
R115 OPP.n2 OPP.t10 25.9898
R116 OPP OPP.t8 18.8045
R117 OPP OPP.t9 18.8045
R118 OPP OPP.t6 18.6585
R119 OPP OPP.t7 18.6585
R120 OPP.n6 OPP 13.8823
R121 OPP.n1 OPP 13.8552
R122 OPP.n12 OPP.n11 10.3205
R123 OPP OPP.n12 9.7385
R124 OPP.n9 OPP 9.4235
R125 OPP.n11 OPP.n10 6.3005
R126 OPP.n7 OPP.n1 5.9705
R127 OPP.n5 OPP.n2 5.23263
R128 OPP OPP.n8 5.2005
R129 OPP OPP.n0 5.2005
R130 OPP.n8 OPP.t4 4.9005
R131 OPP.n8 OPP.t5 4.9005
R132 OPP.n0 OPP.t1 4.9005
R133 OPP.n0 OPP.t2 4.9005
R134 OPP.n7 OPP.n6 4.67727
R135 OPP.n6 OPP 4.51175
R136 OPP.n1 OPP 4.50725
R137 OPP.n5 OPP.n4 4.5005
R138 OPP.n10 OPP.t3 4.4105
R139 OPP.n10 OPP.t0 4.4105
R140 OPP.n6 OPP.n5 0.885547
R141 OPP.n9 OPP.n7 0.5015
R142 OPP.n12 OPP.n9 0.3245
R143 OPP.n4 OPP 0.02975
R144 OPP.n2 OPP 0.005
R145 OPP.n11 OPP 0.00275
R146 OP.n0 OP.t0 11.3405
R147 OP.n0 OP 10.2095
R148 OP OP.n0 0.01175
R149 AN AN.t9 18.8045
R150 AN AN.t10 18.8045
R151 AN AN.t11 18.8045
R152 AN AN.t8 18.8045
R153 AN AN.t6 18.6585
R154 AN AN.t7 18.6585
R155 AN.n7 AN.t5 18.6585
R156 AN AN.t4 18.6585
R157 AN.n5 AN.n4 14.9009
R158 AN.n0 AN 9.4475
R159 AN.n9 AN 9.37175
R160 AN AN.n10 9.37175
R161 AN.n10 AN 9.01175
R162 AN.n8 AN 6.36712
R163 AN.n6 AN.n5 5.75729
R164 AN.n5 AN.n2 5.21086
R165 AN.n4 AN.n3 5.2005
R166 AN.n2 AN.n1 5.2005
R167 AN.n3 AN.t2 4.9005
R168 AN.n3 AN.t3 4.9005
R169 AN.n1 AN.t1 4.9005
R170 AN.n1 AN.t0 4.9005
R171 AN.n8 AN 4.51175
R172 AN.n9 AN.n8 4.5005
R173 AN.n6 AN.n0 0.814413
R174 AN.n10 AN.n9 0.3005
R175 AN.n0 AN 0.207891
R176 AN.n7 AN.n6 0.196152
R177 AN.n4 AN 0.0218158
R178 AN.n2 AN 0.00997368
R179 AN AN.n7 0.00523684
R180 ONN ONN.n7 25.9898
R181 ONN.n6 ONN.t9 25.9898
R182 ONN ONN.t8 18.8045
R183 ONN ONN.t7 18.8045
R184 ONN ONN.t6 18.6585
R185 ONN.n9 ONN 13.8823
R186 ONN ONN.n11 13.8748
R187 ONN.n3 ONN.n2 10.1135
R188 ONN.n3 ONN 9.9215
R189 ONN.n5 ONN 9.63275
R190 ONN.n2 ONN.n1 6.3005
R191 ONN.n11 ONN.n10 5.7185
R192 ONN.n8 ONN.n6 5.23513
R193 ONN ONN.n4 5.2005
R194 ONN ONN.n0 5.2005
R195 ONN.n4 ONN.t4 4.9005
R196 ONN.n4 ONN.t3 4.9005
R197 ONN.n0 ONN.t1 4.9005
R198 ONN.n0 ONN.t0 4.9005
R199 ONN.n10 ONN.n9 4.88675
R200 ONN.n9 ONN 4.51175
R201 ONN.n11 ONN 4.50241
R202 ONN.n8 ONN 4.5005
R203 ONN.n1 ONN.t2 4.4105
R204 ONN.n1 ONN.t5 4.4105
R205 ONN.n9 ONN.n8 0.882369
R206 ONN.n10 ONN.n5 0.4895
R207 ONN.n5 ONN.n3 0.3515
R208 ONN.n6 ONN 0.005
R209 ONN.n2 ONN 0.00275
R210 AP AP.t10 18.8045
R211 AP AP.t11 18.8045
R212 AP AP.t9 18.8045
R213 AP AP.t8 18.8045
R214 AP AP.t5 18.6585
R215 AP AP.t6 18.6585
R216 AP AP.t7 18.6585
R217 AP AP.t4 18.6585
R218 AP.n6 AP.n5 14.9009
R219 AP.n1 AP 9.45425
R220 AP.n0 AP 9.37475
R221 AP AP.n9 9.37175
R222 AP.n0 AP 9.014
R223 AP.n8 AP 6.36807
R224 AP.n7 AP.n6 5.75729
R225 AP.n6 AP.n3 5.21086
R226 AP.n5 AP.n4 5.2005
R227 AP.n3 AP.n2 5.2005
R228 AP.n4 AP.t0 4.9005
R229 AP.n4 AP.t3 4.9005
R230 AP.n2 AP.t1 4.9005
R231 AP.n2 AP.t2 4.9005
R232 AP.n8 AP 4.51175
R233 AP.n9 AP.n8 4.5005
R234 AP.n7 AP.n1 0.806587
R235 AP.n9 AP.n0 0.2975
R236 AP.n1 AP 0.215717
R237 AP AP.n7 0.196152
R238 AP.n5 AP 0.00760526
R239 AP.n3 AP 0.00523684
R240 ON.n0 ON.t0 11.3405
R241 ON.n0 ON 10.2367
R242 ON ON.n0 0.005
R243 CLKK CLKK.t2 18.8045
R244 CLKK CLKK.t3 18.8045
R245 CLKK.n0 CLKK.t4 18.8045
R246 CLKK CLKK.t5 18.8045
R247 CLKK CLKK.t6 18.8045
R248 CLKK CLKK.t7 18.8045
R249 CLKK.n5 CLKK.n4 18.6585
R250 CLKK.n11 CLKK.n10 18.6585
R251 CLKK.n9 CLKK.n8 18.6585
R252 CLKK.n7 CLKK.n6 18.6585
R253 CLKK.n5 CLKK 13.9084
R254 CLKK.n1 CLKK.t0 11.3405
R255 CLKK CLKK.t1 8.84162
R256 CLKK.n3 CLKK.n2 8.43129
R257 CLKK.n2 CLKK.n1 5.74255
R258 CLKK.n2 CLKK 4.5005
R259 CLKK CLKK.n9 0.448132
R260 CLKK CLKK.n7 0.429184
R261 CLKK CLKK.n11 0.426816
R262 CLKK CLKK.n3 0.207891
R263 CLKK.n3 CLKK.n0 0.117968
R264 CLKK.n7 CLKK 0.0241842
R265 CLKK CLKK.n5 0.0241842
R266 CLKK.n9 CLKK 0.0218158
R267 CLKK.n1 CLKK 0.0095
R268 CLKK.n0 CLKK 0.00517532
R269 CLKK.n11 CLKK 0.00286842
R270 CLKN CLKN.t2 25.9898
R271 CLKN.n1 CLKN.t1 11.3405
R272 CLKN.n3 CLKN.n2 9.4445
R273 CLKN.n0 CLKN.t0 8.8405
R274 CLKN.n2 CLKN.n1 5.1155
R275 CLKN.n2 CLKN.n0 5.11307
R276 CLKN CLKN.n3 4.93025
R277 CLKN.n3 CLKN 4.90175
R278 CLKN.n1 CLKN 0.00275
R279 CLKN.n0 CLKN 0.00159756
R280 CLK.n0 CLK.t0 25.9898
R281 CLK.n1 CLK.t1 25.9898
R282 CLK.n1 CLK.n0 9.83562
R283 CLK.n0 CLK 0.00275
R284 CLK CLK.n1 0.001625
R285 NT NT.t12 11.0816
R286 NT.n1 NT.t7 11.0805
R287 NT.n0 NT.t0 11.0805
R288 NT.n17 NT.t4 11.0805
R289 NT.n17 NT.n16 9.94679
R290 NT.n2 NT.n0 9.92279
R291 NT.n5 NT.n4 9.60479
R292 NT.n15 NT.n14 9.60479
R293 NT.n10 NT.n9 9.60479
R294 NT.n2 NT.n1 9.40663
R295 NT.n7 NT 9.40228
R296 NT.n12 NT 9.40228
R297 NT.n16 NT 9.40228
R298 NT NT.n6 5.20163
R299 NT NT.n11 5.20163
R300 NT.n4 NT.n3 5.2005
R301 NT.n14 NT.n13 5.2005
R302 NT.n9 NT.n8 5.2005
R303 NT.n8 NT.t13 4.9005
R304 NT.n8 NT.t3 4.9005
R305 NT.n6 NT.t9 4.9005
R306 NT.n6 NT.t8 4.9005
R307 NT.n3 NT.t6 4.9005
R308 NT.n3 NT.t2 4.9005
R309 NT.n11 NT.t11 4.9005
R310 NT.n11 NT.t10 4.9005
R311 NT.n13 NT.t5 4.9005
R312 NT.n13 NT.t1 4.9005
R313 NT.n5 NT.n2 0.3635
R314 NT.n10 NT.n7 0.3425
R315 NT.n15 NT.n12 0.3425
R316 NT.n16 NT.n15 0.3395
R317 NT.n7 NT.n5 0.3185
R318 NT.n12 NT.n10 0.3185
R319 NT.n0 NT 0.0185
R320 NT.n14 NT 0.01175
R321 NT.n4 NT 0.005
R322 NT.n9 NT 0.005
R323 NT NT.n17 0.003875
R324 NT.n1 NT 0.001625
R325 VIP.n1 VIP.t2 18.8158
R326 VIP VIP.t3 18.8135
R327 VIP VIP.t1 18.809
R328 VIP VIP.t0 18.8045
R329 VIP.n0 VIP 9.31175
R330 VIP VIP.n2 9.30275
R331 VIP.n0 VIP 9.00725
R332 VIP.n2 VIP.n1 9.0005
R333 VIP.n2 VIP.n0 0.3605
R334 VIP.n1 VIP 0.00725
R335 VIN.n1 VIN.t2 18.8158
R336 VIN.n4 VIN.t0 18.8158
R337 VIN.n0 VIN.t3 18.8045
R338 VIN VIN.t1 18.8045
R339 VIN.n2 VIN.n0 9.31475
R340 VIN.n4 VIN.n3 9.3005
R341 VIN.n3 VIN 9.01175
R342 VIN.n2 VIN.n1 9.0005
R343 VIN.n3 VIN.n2 0.3605
R344 VIN.n1 VIN 0.02975
R345 VIN VIN.n4 0.023
R346 VIN.n0 VIN 0.01175
R347 CP.n5 CP.n2 10.4208
R348 CP.n5 CP.n4 9.67879
R349 CP.n4 CP.n3 6.3005
R350 CP CP.n7 6.3005
R351 CP.n2 CP.n1 6.3005
R352 CP.n6 CP 5.65443
R353 CP CP.n0 5.2005
R354 CP CP.n6 5.19768
R355 CP.n6 CP.n5 5.1845
R356 CP.n0 CP.t3 4.9005
R357 CP.n0 CP.t0 4.9005
R358 CP.n1 CP.t7 4.4105
R359 CP.n1 CP.t4 4.4105
R360 CP.n3 CP.t1 4.4105
R361 CP.n3 CP.t6 4.4105
R362 CP.n7 CP.t5 4.4105
R363 CP.n7 CP.t2 4.4105
R364 CP.n4 CP 0.00275
R365 CP.n2 CP 0.00275
R366 CN.n7 CN.n6 10.4109
R367 CN.n6 CN.n5 9.68193
R368 CN CN.n2 6.3005
R369 CN.n7 CN.n0 6.3005
R370 CN.n5 CN.n4 6.3005
R371 CN.n3 CN 5.65346
R372 CN CN.n1 5.2005
R373 CN.n3 CN 5.19543
R374 CN.n6 CN.n3 5.1875
R375 CN.n1 CN.t1 4.9005
R376 CN.n1 CN.t0 4.9005
R377 CN.n4 CN.t6 4.4105
R378 CN.n4 CN.t5 4.4105
R379 CN.n2 CN.t4 4.4105
R380 CN.n2 CN.t2 4.4105
R381 CN.n0 CN.t3 4.4105
R382 CN.n0 CN.t7 4.4105
R383 CN CN.n7 0.014
R384 CN.n5 CN 0.0095
C0 CLK w_8626_n16372# 0.17396f
C1 m3_8756_n16674# CLKK 0.00309f
C2 VSS ON 0.19137f
C3 m3_10090_n11336# OPP 0.01839f
C4 VIP AP 0.12684f
C5 AP NT 0.18298f
C6 CLKK a_9964_n16840# 0
C7 CLKN CLKK 0.31001f
C8 m3_8756_n16674# w_8626_n16372# 0.04063f
C9 AP VSS 0.81642f
C10 ONN CP 0.42699f
C11 m3_10090_n11336# VDD 0.20362f
C12 a_10336_n13624# OPP 0.00897f
C13 CLKN w_8626_n16372# 0.14948f
C14 a_8996_n13492# NT 0
C15 a_8996_n13492# VSS 0.01268f
C16 a_10336_n13624# VDD 0.00146f
C17 a_10916_n13492# CP 0.00205f
C18 VIN AN 0.1286f
C19 AN OPP 0.33141f
C20 OP OPP 0.3243f
C21 VDD AN 0.87782f
C22 VDD OP 0.12074f
C23 AN CN 1.00422f
C24 CN OP 0
C25 CLKK w_8626_n16372# 1.57688f
C26 VIP CP 0
C27 VSS CP 0.60459f
C28 ONN OPP 2.63194f
C29 AP ON 0
C30 ONN VDD 0.90777f
C31 CLKK w_8240_n12868# 0
C32 ONN CN 0.34812f
C33 a_10916_n13492# VDD 0
C34 VIP VIN 0.05926f
C35 VIN NT 0.48927f
C36 NT OPP 0.0013f
C37 VIN VSS 0.05001f
C38 VSS OPP 0.6252f
C39 a_10054_n16107# VDD 0.01126f
C40 VIP VDD 0.34407f
C41 VDD NT 1.72594f
C42 ON CP 0
C43 VDD VSS 3.26758f
C44 CLKN AN 0
C45 VSS CN 0.57406f
C46 AP CP 1.00848f
C47 a_10336_n13624# CLKK 0.00511f
C48 VSS a_9960_n15971# 0
C49 a_10336_n13624# w_8626_n16372# 0
C50 AN CLKK 0.11709f
C51 m3_10090_n11336# w_8240_n12868# 0.05897f
C52 AN w_8626_n16372# 0.15987f
C53 m3_10090_n11336# a_11398_n12302# 0
C54 ON OPP 0.03646f
C55 a_10054_n16107# CLK 0.0257f
C56 a_10336_n13624# w_8240_n12868# 0.00191f
C57 AP VIN 0.0011f
C58 VDD ON 0.12021f
C59 CLK NT 0
C60 AP OPP 0.30412f
C61 VSS CLK 0.13228f
C62 ONN CLKK 0.00284f
C63 AN w_8240_n12868# 0.8529f
C64 a_8996_n13492# VIN 0
C65 VDD AP 0.8206f
C66 m3_8756_n16674# NT 0
C67 w_8240_n12868# OP 0.08434f
C68 AP CN 0.00221f
C69 a_10054_n16107# CLKN 0.02163f
C70 m3_8756_n16674# VSS 0.072f
C71 VIP CLKN 0
C72 ONN w_8626_n16372# 0.00267f
C73 CLKN NT 0.01027f
C74 VDD a_8996_n13492# 0
C75 VSS a_9964_n16840# 0.00987f
C76 CLKN VSS 0.36111f
C77 a_8996_n13492# CN 0.00208f
C78 ONN w_8240_n12868# 0.71376f
C79 ONN a_11398_n12302# 0
C80 a_10054_n16107# CLKK 0.01596f
C81 CP OPP 0.22285f
C82 VIP CLKK 0.07076f
C83 NT CLKK 0.45772f
C84 a_10054_n16107# w_8626_n16372# 0.13761f
C85 VSS CLKK 1.06148f
C86 VIP w_8626_n16372# 0.8627f
C87 VDD CP 0.23928f
C88 NT w_8626_n16372# 0.5833f
C89 CN CP 0.0588f
C90 VSS w_8626_n16372# 0.25568f
C91 a_10336_n13624# AN 0
C92 VSS w_8240_n12868# 0.17773f
C93 AN OP 0
C94 m3_10090_n11336# ONN 0.02951f
C95 VSS a_11398_n12302# 0
C96 VIN OPP 0.0028f
C97 VDD VIN 0.44193f
C98 ONN a_10336_n13624# 0.05229f
C99 VDD OPP 1.24263f
C100 VIN CN 0
C101 CN OPP 0.31283f
C102 ONN AN 0.22765f
C103 VDD CN 0.27578f
C104 AP CLKK 0.31973f
C105 ONN OP 0.03637f
C106 AP w_8626_n16372# 0.14931f
C107 VDD a_9960_n15971# 0.00905f
C108 m3_10090_n11336# VSS 0.11963f
C109 w_8240_n12868# ON 0.08439f
C110 VIP a_10336_n13624# 0
C111 a_10336_n13624# VSS 0.01095f
C112 AP w_8240_n12868# 0.85458f
C113 VIP AN 0.0011f
C114 AN NT 0.1816f
C115 VIN CLK 0.00264f
C116 VSS AN 0.76317f
C117 CLKK CP 0
C118 VSS OP 0.18505f
C119 VDD CLK 0.12023f
C120 m3_8756_n16674# VIN 0
C121 w_8626_n16372# CP 0.00162f
C122 CLKN VIN 0.00215f
C123 m3_8756_n16674# VDD 0.12168f
C124 VIP ONN 0.00211f
C125 ONN NT 0.00117f
C126 VDD a_9964_n16840# 0
C127 m3_10090_n11336# ON 0.04453f
C128 CLKN VDD 0.38456f
C129 CLK a_9960_n15971# 0
C130 ONN VSS 0.60684f
C131 w_8240_n12868# CP 0.08727f
C132 m3_10090_n11336# AP 0.00253f
C133 a_11398_n12302# CP 0.00186f
C134 a_10916_n13492# NT 0
C135 a_10916_n13492# VSS 0.01317f
C136 VIN CLKK 0.0207f
C137 CLKN a_9960_n15971# 0.00123f
C138 CLKK OPP 0.00792f
C139 a_10336_n13624# AP 0.05084f
C140 ON OP 0.00583f
C141 VIN w_8626_n16372# 0.85544f
C142 w_8626_n16372# OPP 0.00288f
C143 VDD CLKK 1.30102f
C144 VIP a_10054_n16107# 0
C145 a_10054_n16107# NT 0
C146 AP AN 0.14696f
C147 VIP NT 0.48291f
C148 CN CLKK 0
C149 a_10054_n16107# VSS 0
C150 VDD w_8626_n16372# 3.23503f
C151 VIP VSS 0.09628f
C152 VSS NT 0.03182f
C153 CN w_8626_n16372# 0
C154 a_8996_n13492# AN 0.00271f
C155 m3_8756_n16674# CLK 0.0232f
C156 a_9960_n15971# CLKK 0.00138f
C157 w_8240_n12868# OPP 0.80351f
C158 ONN ON 0.27943f
C159 m3_10090_n11336# CP 0
C160 CLK a_9964_n16840# 0
C161 CLKN CLK 0.60579f
C162 VDD w_8240_n12868# 2.62464f
C163 ONN AP 0.20254f
C164 CN w_8240_n12868# 0.0853f
C165 VDD a_11398_n12302# 0.01199f
C166 a_10336_n13624# CP 0.00875f
C167 m3_8756_n16674# a_9964_n16840# 0
C168 m3_8756_n16674# CLKN 0.09452f
C169 CLKN a_9964_n16840# 0.00106f
C170 a_10916_n13492# AP 0.00275f
C171 AN CP 0.00222f
C172 CLK CLKK 0.02546f
C173 VSS pfet_0/VSUBS -3.14313f
C174 m3_8756_n16674# pfet_0/VSUBS 0.22857f $ **FLOATING
C175 VIP pfet_0/VSUBS 0.19432f
C176 VIN pfet_0/VSUBS -0.10416f
C177 AP pfet_0/VSUBS 1.02991f
C178 AN pfet_0/VSUBS 0.96501f
C179 m3_10090_n11336# pfet_0/VSUBS 0.42091f $ **FLOATING
C180 CLKN pfet_0/VSUBS -0.14014f
C181 CP pfet_0/VSUBS -0.48482f
C182 OPP pfet_0/VSUBS 0.42273f
C183 ONN pfet_0/VSUBS -0.78069f
C184 CN pfet_0/VSUBS -0.47207f
C185 a_10054_n16107# pfet_0/VSUBS 0.00449f
C186 a_10336_n13624# pfet_0/VSUBS 0.20326f
C187 w_8626_n16372# pfet_0/VSUBS 16.8731f
C188 CN.t3 pfet_0/VSUBS 0.0056f
C189 CN.t7 pfet_0/VSUBS 0.0056f
C190 CN.n0 pfet_0/VSUBS 0.0112f
C191 CN.t1 pfet_0/VSUBS 0.0056f
C192 CN.t0 pfet_0/VSUBS 0.0056f
C193 CN.n1 pfet_0/VSUBS 0.0112f
C194 CN.t4 pfet_0/VSUBS 0.0056f
C195 CN.t2 pfet_0/VSUBS 0.0056f
C196 CN.n2 pfet_0/VSUBS 0.0112f
C197 CN.n3 pfet_0/VSUBS 0.1151f
C198 CN.t6 pfet_0/VSUBS 0.0056f
C199 CN.t5 pfet_0/VSUBS 0.0056f
C200 CN.n4 pfet_0/VSUBS 0.0112f
C201 CN.n5 pfet_0/VSUBS 0.03235f
C202 CN.n6 pfet_0/VSUBS 0.15534f
C203 CN.n7 pfet_0/VSUBS 0.03663f
C204 CP.t3 pfet_0/VSUBS 0.00543f
C205 CP.t0 pfet_0/VSUBS 0.00543f
C206 CP.n0 pfet_0/VSUBS 0.01087f
C207 CP.t7 pfet_0/VSUBS 0.00543f
C208 CP.t4 pfet_0/VSUBS 0.00543f
C209 CP.n1 pfet_0/VSUBS 0.01087f
C210 CP.n2 pfet_0/VSUBS 0.035f
C211 CP.t1 pfet_0/VSUBS 0.00543f
C212 CP.t6 pfet_0/VSUBS 0.00543f
C213 CP.n3 pfet_0/VSUBS 0.01087f
C214 CP.n4 pfet_0/VSUBS 0.03142f
C215 CP.n5 pfet_0/VSUBS 0.15157f
C216 CP.n6 pfet_0/VSUBS 0.1118f
C217 CP.t5 pfet_0/VSUBS 0.00543f
C218 CP.t2 pfet_0/VSUBS 0.00543f
C219 CP.n7 pfet_0/VSUBS 0.01087f
C220 VIN.t0 pfet_0/VSUBS 0.13634f
C221 VIN.t3 pfet_0/VSUBS 0.13627f
C222 VIN.n0 pfet_0/VSUBS 0.13948f
C223 VIN.t2 pfet_0/VSUBS 0.13634f
C224 VIN.n1 pfet_0/VSUBS 0.16187f
C225 VIN.n2 pfet_0/VSUBS -0.45493f
C226 VIN.t1 pfet_0/VSUBS 0.13627f
C227 VIN.n3 pfet_0/VSUBS 0.39745f
C228 VIN.n4 pfet_0/VSUBS 0.16437f
C229 VIP.t0 pfet_0/VSUBS 0.13944f
C230 VIP.t1 pfet_0/VSUBS 0.13947f
C231 VIP.n0 pfet_0/VSUBS -0.47801f
C232 VIP.t2 pfet_0/VSUBS 0.13951f
C233 VIP.n1 pfet_0/VSUBS 0.15564f
C234 VIP.n2 pfet_0/VSUBS 0.40661f
C235 VIP.t3 pfet_0/VSUBS 0.13949f
C236 NT.t4 pfet_0/VSUBS 0.01412f
C237 NT.t0 pfet_0/VSUBS 0.01412f
C238 NT.n0 pfet_0/VSUBS 0.04191f
C239 NT.t7 pfet_0/VSUBS 0.01412f
C240 NT.n1 pfet_0/VSUBS 0.0337f
C241 NT.n2 pfet_0/VSUBS 0.0912f
C242 NT.t6 pfet_0/VSUBS 0.00593f
C243 NT.t2 pfet_0/VSUBS 0.00593f
C244 NT.n3 pfet_0/VSUBS 0.01187f
C245 NT.n4 pfet_0/VSUBS 0.03174f
C246 NT.n5 pfet_0/VSUBS 0.05389f
C247 NT.t9 pfet_0/VSUBS 0.00593f
C248 NT.t8 pfet_0/VSUBS 0.00593f
C249 NT.n6 pfet_0/VSUBS 0.01187f
C250 NT.n7 pfet_0/VSUBS 0.04719f
C251 NT.t13 pfet_0/VSUBS 0.00593f
C252 NT.t3 pfet_0/VSUBS 0.00593f
C253 NT.n8 pfet_0/VSUBS 0.01187f
C254 NT.n9 pfet_0/VSUBS 0.03174f
C255 NT.n10 pfet_0/VSUBS 0.05318f
C256 NT.t11 pfet_0/VSUBS 0.00593f
C257 NT.t10 pfet_0/VSUBS 0.00593f
C258 NT.n11 pfet_0/VSUBS 0.01187f
C259 NT.n12 pfet_0/VSUBS 0.04719f
C260 NT.t5 pfet_0/VSUBS 0.00593f
C261 NT.t1 pfet_0/VSUBS 0.00593f
C262 NT.n13 pfet_0/VSUBS 0.01187f
C263 NT.n14 pfet_0/VSUBS 0.03215f
C264 NT.n15 pfet_0/VSUBS 0.05389f
C265 NT.t12 pfet_0/VSUBS 0.01413f
C266 NT.n16 pfet_0/VSUBS 0.09179f
C267 NT.n17 pfet_0/VSUBS 0.04116f
C268 CLK.t0 pfet_0/VSUBS 0.06684f
C269 CLK.n0 pfet_0/VSUBS 0.34924f
C270 CLK.t1 pfet_0/VSUBS 0.06923f
C271 CLK.n1 pfet_0/VSUBS 0.35422f
C272 CLKN.t2 pfet_0/VSUBS 0.02143f
C273 CLKN.t0 pfet_0/VSUBS 0.03113f
C274 CLKN.n0 pfet_0/VSUBS 0.03689f
C275 CLKN.t1 pfet_0/VSUBS 0.03229f
C276 CLKN.n1 pfet_0/VSUBS 0.03482f
C277 CLKN.n2 pfet_0/VSUBS 0.29007f
C278 CLKN.n3 pfet_0/VSUBS 0.20984f
C279 CLKK.t2 pfet_0/VSUBS 0.05306f
C280 CLKK.t7 pfet_0/VSUBS 0.05306f
C281 CLKK.t6 pfet_0/VSUBS 0.05306f
C282 CLKK.t5 pfet_0/VSUBS 0.05306f
C283 CLKK.t4 pfet_0/VSUBS 0.05306f
C284 CLKK.n0 pfet_0/VSUBS 0.04992f
C285 CLKK.t0 pfet_0/VSUBS 0.04066f
C286 CLKK.n1 pfet_0/VSUBS 0.06691f
C287 CLKK.t1 pfet_0/VSUBS 0.04199f
C288 CLKK.n2 pfet_0/VSUBS 0.32464f
C289 CLKK.n3 pfet_0/VSUBS 0.07438f
C290 CLKK.t3 pfet_0/VSUBS 0.05306f
C291 CLKK.n4 pfet_0/VSUBS 0.05215f
C292 CLKK.n5 pfet_0/VSUBS 0.44367f
C293 CLKK.n6 pfet_0/VSUBS 0.05215f
C294 CLKK.n7 pfet_0/VSUBS 0.06552f
C295 CLKK.n8 pfet_0/VSUBS 0.05215f
C296 CLKK.n9 pfet_0/VSUBS 0.0665f
C297 CLKK.n10 pfet_0/VSUBS 0.05215f
C298 CLKK.n11 pfet_0/VSUBS 0.06211f
C299 ON.t0 pfet_0/VSUBS 0.0853f
C300 ON.n0 pfet_0/VSUBS 0.36857f
C301 AP.t11 pfet_0/VSUBS 0.07812f
C302 AP.t10 pfet_0/VSUBS 0.07812f
C303 AP.n0 pfet_0/VSUBS 0.23577f
C304 AP.t9 pfet_0/VSUBS 0.07812f
C305 AP.t4 pfet_0/VSUBS 0.0264f
C306 AP.t5 pfet_0/VSUBS 0.0264f
C307 AP.t7 pfet_0/VSUBS 0.0264f
C308 AP.n1 pfet_0/VSUBS 0.20725f
C309 AP.t1 pfet_0/VSUBS 0.02449f
C310 AP.t2 pfet_0/VSUBS 0.02449f
C311 AP.n2 pfet_0/VSUBS 0.04898f
C312 AP.n3 pfet_0/VSUBS 0.0371f
C313 AP.t0 pfet_0/VSUBS 0.02449f
C314 AP.t3 pfet_0/VSUBS 0.02449f
C315 AP.n4 pfet_0/VSUBS 0.04898f
C316 AP.n5 pfet_0/VSUBS 0.26483f
C317 AP.n6 pfet_0/VSUBS 0.75995f
C318 AP.n7 pfet_0/VSUBS 0.15295f
C319 AP.t6 pfet_0/VSUBS 0.0264f
C320 AP.n8 pfet_0/VSUBS 0.43883f
C321 AP.n9 pfet_0/VSUBS 0.21251f
C322 AP.t8 pfet_0/VSUBS 0.07812f
C323 ONN.t1 pfet_0/VSUBS 0.016f
C324 ONN.t0 pfet_0/VSUBS 0.016f
C325 ONN.n0 pfet_0/VSUBS 0.032f
C326 ONN.t2 pfet_0/VSUBS 0.016f
C327 ONN.t5 pfet_0/VSUBS 0.016f
C328 ONN.n1 pfet_0/VSUBS 0.032f
C329 ONN.n2 pfet_0/VSUBS 0.13776f
C330 ONN.n3 pfet_0/VSUBS 0.31822f
C331 ONN.t4 pfet_0/VSUBS 0.016f
C332 ONN.t3 pfet_0/VSUBS 0.016f
C333 ONN.n4 pfet_0/VSUBS 0.032f
C334 ONN.n5 pfet_0/VSUBS 0.16676f
C335 ONN.t9 pfet_0/VSUBS 0.02595f
C336 ONN.n6 pfet_0/VSUBS 0.05108f
C337 ONN.n7 pfet_0/VSUBS 0.02688f
C338 ONN.n8 pfet_0/VSUBS 0.23425f
C339 ONN.t7 pfet_0/VSUBS 0.05103f
C340 ONN.t8 pfet_0/VSUBS 0.05103f
C341 ONN.n9 pfet_0/VSUBS 0.25775f
C342 ONN.n10 pfet_0/VSUBS 0.05912f
C343 ONN.n11 pfet_0/VSUBS 0.2674f
C344 ONN.t6 pfet_0/VSUBS 0.01633f
C345 AN.t11 pfet_0/VSUBS 0.07138f
C346 AN.t10 pfet_0/VSUBS 0.07138f
C347 AN.t4 pfet_0/VSUBS 0.02413f
C348 AN.n0 pfet_0/VSUBS 0.18935f
C349 AN.t1 pfet_0/VSUBS 0.02238f
C350 AN.t0 pfet_0/VSUBS 0.02238f
C351 AN.n1 pfet_0/VSUBS 0.04475f
C352 AN.n2 pfet_0/VSUBS 0.03487f
C353 AN.t2 pfet_0/VSUBS 0.02238f
C354 AN.t3 pfet_0/VSUBS 0.02238f
C355 AN.n3 pfet_0/VSUBS 0.04475f
C356 AN.n4 pfet_0/VSUBS 0.24489f
C357 AN.n5 pfet_0/VSUBS 0.69436f
C358 AN.n6 pfet_0/VSUBS 0.14034f
C359 AN.t5 pfet_0/VSUBS 0.19198f
C360 AN.n7 pfet_0/VSUBS 0.06741f
C361 AN.t6 pfet_0/VSUBS 0.02413f
C362 AN.t7 pfet_0/VSUBS 0.02413f
C363 AN.n8 pfet_0/VSUBS 0.41264f
C364 AN.n9 pfet_0/VSUBS 0.19456f
C365 AN.t9 pfet_0/VSUBS 0.07138f
C366 AN.n10 pfet_0/VSUBS 0.21507f
C367 AN.t8 pfet_0/VSUBS 0.07138f
C368 OP.t0 pfet_0/VSUBS 0.03603f
C369 OP.n0 pfet_0/VSUBS 0.1554f
C370 OPP.t1 pfet_0/VSUBS 0.03246f
C371 OPP.t2 pfet_0/VSUBS 0.03246f
C372 OPP.n0 pfet_0/VSUBS 0.06492f
C373 OPP.t7 pfet_0/VSUBS 0.035f
C374 OPP.t6 pfet_0/VSUBS 0.035f
C375 OPP.n1 pfet_0/VSUBS 0.60594f
C376 OPP.t10 pfet_0/VSUBS 0.05266f
C377 OPP.n2 pfet_0/VSUBS -0.03785f
C378 OPP.n3 pfet_0/VSUBS 0.05454f
C379 OPP.n4 pfet_0/VSUBS 0.09028f
C380 OPP.n5 pfet_0/VSUBS -0.39542f
C381 OPP.t9 pfet_0/VSUBS 0.10354f
C382 OPP.t8 pfet_0/VSUBS 0.10354f
C383 OPP.n6 pfet_0/VSUBS 0.45243f
C384 OPP.n7 pfet_0/VSUBS 0.1647f
C385 OPP.t4 pfet_0/VSUBS 0.03246f
C386 OPP.t5 pfet_0/VSUBS 0.03246f
C387 OPP.n8 pfet_0/VSUBS 0.06492f
C388 OPP.n9 pfet_0/VSUBS 0.29706f
C389 OPP.t3 pfet_0/VSUBS 0.03246f
C390 OPP.t0 pfet_0/VSUBS 0.03246f
C391 OPP.n10 pfet_0/VSUBS 0.06492f
C392 OPP.n11 pfet_0/VSUBS 0.29203f
C393 OPP.n12 pfet_0/VSUBS 0.61646f
C394 VDD.n0 pfet_0/VSUBS 0.04561f
C395 VDD.n1 pfet_0/VSUBS 0.04821f
C396 VDD.n2 pfet_0/VSUBS 0.0152f
C397 VDD.n3 pfet_0/VSUBS 0.55401f
C398 VDD.n4 pfet_0/VSUBS 0.54337f
C399 VDD.n5 pfet_0/VSUBS 0.26702f
C400 VDD.n6 pfet_0/VSUBS 0.243f
C401 VDD.t3 pfet_0/VSUBS 0.0035f
C402 VDD.t4 pfet_0/VSUBS 0.0035f
C403 VDD.n7 pfet_0/VSUBS 0.007f
C404 VDD.n8 pfet_0/VSUBS 0.05863f
C405 VDD.t6 pfet_0/VSUBS 0.0035f
C406 VDD.t15 pfet_0/VSUBS 0.0035f
C407 VDD.n9 pfet_0/VSUBS 0.007f
C408 VDD.n10 pfet_0/VSUBS 0.00846f
C409 VDD.n11 pfet_0/VSUBS 0.03556f
C410 VDD.t16 pfet_0/VSUBS 0.0035f
C411 VDD.t1 pfet_0/VSUBS 0.0035f
C412 VDD.n12 pfet_0/VSUBS 0.007f
C413 VDD.n13 pfet_0/VSUBS 0.0355f
C414 VDD.t2 pfet_0/VSUBS 0.0035f
C415 VDD.t7 pfet_0/VSUBS 0.0035f
C416 VDD.n14 pfet_0/VSUBS 0.007f
C417 VDD.n15 pfet_0/VSUBS 0.03556f
C418 VDD.t8 pfet_0/VSUBS 0.0035f
C419 VDD.t9 pfet_0/VSUBS 0.0035f
C420 VDD.n16 pfet_0/VSUBS 0.007f
C421 VDD.n17 pfet_0/VSUBS 0.03598f
C422 VDD.t10 pfet_0/VSUBS 0.00833f
C423 VDD.n18 pfet_0/VSUBS 0.0276f
C424 VDD.n19 pfet_0/VSUBS 0.04167f
C425 VDD.n20 pfet_0/VSUBS 0.64931f
C426 VDD.n21 pfet_0/VSUBS 0.3725f
C427 VDD.n22 pfet_0/VSUBS 0.05487f
C428 VDD.n23 pfet_0/VSUBS 0.19954f
C429 VDD.n24 pfet_0/VSUBS 0.4978f
C430 VDD.n25 pfet_0/VSUBS 1.40956f
C431 VDD.n26 pfet_0/VSUBS 1.23474f
C432 VDD.n27 pfet_0/VSUBS 1.89844f
C433 VDD.n28 pfet_0/VSUBS 0.14433f
C434 VDD.n29 pfet_0/VSUBS 0.68343f
C435 VDD.n30 pfet_0/VSUBS 0.32497f
C436 VDD.n31 pfet_0/VSUBS 0.17883f
C437 VDD.n32 pfet_0/VSUBS 0.16911f
C438 VDD.n33 pfet_0/VSUBS 0.43592f
C439 VDD.n34 pfet_0/VSUBS 1.67331f
C440 VDD.n35 pfet_0/VSUBS 0.11504f
C441 VDD.n36 pfet_0/VSUBS 0.03821f
C442 VDD.n37 pfet_0/VSUBS 0.0345f
C443 VDD.t14 pfet_0/VSUBS 0.0035f
C444 VDD.t5 pfet_0/VSUBS 0.0035f
C445 VDD.n38 pfet_0/VSUBS 0.007f
C446 VDD.n39 pfet_0/VSUBS 0.04339f
C447 VDD.t12 pfet_0/VSUBS 0.0035f
C448 VDD.t13 pfet_0/VSUBS 0.0035f
C449 VDD.n40 pfet_0/VSUBS 0.007f
C450 VDD.n41 pfet_0/VSUBS 0.05776f
C451 VDD.t0 pfet_0/VSUBS 0.0035f
C452 VDD.t11 pfet_0/VSUBS 0.0035f
C453 VDD.n42 pfet_0/VSUBS 0.007f
C454 VSS.n0 pfet_0/VSUBS 2.21092f
C455 VSS.n1 pfet_0/VSUBS 0.0289f
C456 VSS.n2 pfet_0/VSUBS 0.02633f
C457 VSS.n3 pfet_0/VSUBS 0.22102f
C458 VSS.t2 pfet_0/VSUBS 0.00413f
C459 VSS.n4 pfet_0/VSUBS 0.00643f
C460 VSS.n5 pfet_0/VSUBS 0.03406f
C461 VSS.t0 pfet_0/VSUBS 0.00165f
C462 VSS.t4 pfet_0/VSUBS 0.00165f
C463 VSS.n6 pfet_0/VSUBS 0.00331f
C464 VSS.n7 pfet_0/VSUBS 0.03041f
C465 VSS.n8 pfet_0/VSUBS 0.0236f
C466 VSS.t5 pfet_0/VSUBS 0.00424f
C467 VSS.n9 pfet_0/VSUBS 0.00566f
C468 VSS.n10 pfet_0/VSUBS 0.01303f
C469 VSS.n11 pfet_0/VSUBS 0.22017f
C470 VSS.n12 pfet_0/VSUBS 1.90932f
C471 VSS.t3 pfet_0/VSUBS 0.00189f
C472 VSS.t1 pfet_0/VSUBS 0.00189f
C473 VSS.n13 pfet_0/VSUBS 0.00378f
C474 VSS.n14 pfet_0/VSUBS 0.02581f
C475 CLK pfet_0/VSUBS 0.13338f
C476 NT pfet_0/VSUBS -1.73996f
C477 VDD pfet_0/VSUBS -9.93555f
C478 CLKK pfet_0/VSUBS 0.79475f
C479 OP pfet_0/VSUBS -0.02573f
C480 ON pfet_0/VSUBS 0.267f
C481 w_8240_n12868# pfet_0/VSUBS 13.20748f
.ends
